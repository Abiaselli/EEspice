* 28T 1bit full Adder

* Models
.model NMOS nmos (level=14 version=4.8.2)
.model PMOS pmos (level=14 version=4.8.2)

* Simulation flags
.options acct
*.options num_threads=32
*.sparse

M1 VDD A N003 VDD PMOS l=1u w=4u
M2 N003 B N005 VDD PMOS l=1u w=4u
M3 VDD A N001 VDD PMOS l=1u w=4u
M4 N001 Ci N005 VDD PMOS l=1u w=4u
M5 VDD B N001 VDD PMOS l=1u w=4u
M6 VDD N005 Co VDD PMOS l=1u w=2u
M7 VDD A N002 VDD PMOS l=1u w=4u
M8 VDD B N002 VDD PMOS l=1u w=4u
M9 VDD Ci N002 VDD PMOS l=1u w=4u
M10 VDD A N004 VDD PMOS l=1u w=8u
M11 N004 B N006 VDD PMOS l=1u w=8u
M12 N006 Ci N007 VDD PMOS l=1u w=8u
M13 N007 Ci N008 0 NMOS l=1u w=8u
M14 N008 B N012 0 NMOS l=1u w=8u
M15 N012 A 0 0 NMOS l=1u w=8u
M16 N010 Ci 0 0 NMOS l=1u w=2u
M17 N010 B 0 0 NMOS l=1u w=2u
M18 N010 A 0 0 NMOS l=1u w=2u
M19 N007 N005 N010 0 NMOS l=1u w=2u
M20 N009 B 0 0 NMOS l=1u w=2u
M21 N009 A 0 0 NMOS l=1u w=2u
M22 N011 A 0 0 NMOS l=1u w=2u
M23 N005 B N011 0 NMOS l=1u w=2u
M24 N005 Ci N009 0 NMOS l=1u w=2u
M25 Co N005 0 0 NMOS l=1u w=1u
M26 N002 N005 N007 VDD PMOS l=1u w=4u
M27 VDD N007 SUM VDD PMOS l=1u w=2u
M28 SUM N007 0 0 NMOS l=1u w=1u
C1 SUM 0 1p
C2 Co 0 1p
V1 VDD 0 1.8
V2 A 0 PULSE (0 1.8 20u 1u 1u 20u 40u)
V3 B 0 PULSE (0 1.8 10u 1u 1u 10u 20u)
V4 Ci 0 PULSE (0 1.8 5u 1u 1u 5u 10u)

.tran 2u 40u

.end
