* 64-bit Ripple Carry Adder - Generated from 28T Res netlist
* Based on provided 1-bit topology

* Models
.model NMOS nmos (level=14 version=4.8.2)
.model PMOS pmos (level=14 version=4.8.2)

* Simulation flags
.options acct
.options num_threads=64
.sparse

V1 VDD 0 1.8

* --- Generated Transistors, Resistors, and Caps ---

* Bit 0
M1 N001_0 A0 N010_0 N001_0 PMOS l=1u w=4u
M2 N010_0 B0 N016_0 N012_0 PMOS l=1u w=4u
M3 N002_0 A0 N008_0 N002_0 PMOS l=1u w=4u
M4 N008_0 Cin N016_0 N013_0 PMOS l=1u w=4u
M5 N003_0 B0 N008_0 N003_0 PMOS l=1u w=4u
M6 VDD N016_0 C0 N020_0 PMOS l=1u w=2u
M7 N004_0 A0 N009_0 N004_0 PMOS l=1u w=4u
M8 N005_0 B0 N009_0 N005_0 PMOS l=1u w=4u
M9 N006_0 Cin N009_0 N006_0 PMOS l=1u w=4u
M10 N007_0 A0 N011_0 N007_0 PMOS l=1u w=8u
M11 N011_0 B0 N017_0 N015_0 PMOS l=1u w=8u
M12 N017_0 Cin N021_0 N018_0 PMOS l=1u w=8u
M13 N021_0 Cin N022_0 0 NMOS l=1u w=8u
M14 N022_0 B0 N026_0 0 NMOS l=1u w=8u
M15 N026_0 A0 0 0 NMOS l=1u w=8u
M16 N024_0 Cin 0 0 NMOS l=1u w=2u
M17 N024_0 B0 0 0 NMOS l=1u w=2u
M18 N024_0 A0 0 0 NMOS l=1u w=2u
M19 N021_0 N016_0 N024_0 0 NMOS l=1u w=2u
M20 N023_0 B0 0 0 NMOS l=1u w=2u
M21 N023_0 A0 0 0 NMOS l=1u w=2u
M22 N025_0 A0 0 0 NMOS l=1u w=2u
M23 N016_0 B0 N025_0 0 NMOS l=1u w=2u
M24 N016_0 Cin N023_0 0 NMOS l=1u w=2u
M25 C0 N016_0 0 0 NMOS l=1u w=1u
M26 N009_0 N016_0 N021_0 N014_0 PMOS l=1u w=4u
M27 N019_0 N021_0 SUM0 N019_0 PMOS l=1u w=2u
M28 SUM0 N021_0 0 0 NMOS l=1u w=1u
R1 VDD N002_0 0.001
R2 VDD N003_0 0.001
R3 VDD N004_0 0.001
R4 VDD N005_0 0.001
R5 VDD N006_0 0.001
R6 VDD N007_0 0.001
R7 VDD N013_0 0.001
R8 N012_0 VDD 0.001
R9 VDD N001_0 0.001
R10 VDD N019_0 0.001
R11 VDD N014_0 0.001
R12 VDD N015_0 0.001
R13 VDD N018_0 0.001
R14 VDD N020_0 0.001
C1 SUM0 0 1p
C2 C0 0 1p

* Bit 1
M29 N001_1 A1 N010_1 N001_1 PMOS l=1u w=4u
M30 N010_1 B1 N016_1 N012_1 PMOS l=1u w=4u
M31 N002_1 A1 N008_1 N002_1 PMOS l=1u w=4u
M32 N008_1 C0 N016_1 N013_1 PMOS l=1u w=4u
M33 N003_1 B1 N008_1 N003_1 PMOS l=1u w=4u
M34 VDD N016_1 C1 N020_1 PMOS l=1u w=2u
M35 N004_1 A1 N009_1 N004_1 PMOS l=1u w=4u
M36 N005_1 B1 N009_1 N005_1 PMOS l=1u w=4u
M37 N006_1 C0 N009_1 N006_1 PMOS l=1u w=4u
M38 N007_1 A1 N011_1 N007_1 PMOS l=1u w=8u
M39 N011_1 B1 N017_1 N015_1 PMOS l=1u w=8u
M40 N017_1 C0 N021_1 N018_1 PMOS l=1u w=8u
M41 N021_1 C0 N022_1 0 NMOS l=1u w=8u
M42 N022_1 B1 N026_1 0 NMOS l=1u w=8u
M43 N026_1 A1 0 0 NMOS l=1u w=8u
M44 N024_1 C0 0 0 NMOS l=1u w=2u
M45 N024_1 B1 0 0 NMOS l=1u w=2u
M46 N024_1 A1 0 0 NMOS l=1u w=2u
M47 N021_1 N016_1 N024_1 0 NMOS l=1u w=2u
M48 N023_1 B1 0 0 NMOS l=1u w=2u
M49 N023_1 A1 0 0 NMOS l=1u w=2u
M50 N025_1 A1 0 0 NMOS l=1u w=2u
M51 N016_1 B1 N025_1 0 NMOS l=1u w=2u
M52 N016_1 C0 N023_1 0 NMOS l=1u w=2u
M53 C1 N016_1 0 0 NMOS l=1u w=1u
M54 N009_1 N016_1 N021_1 N014_1 PMOS l=1u w=4u
M55 N019_1 N021_1 SUM1 N019_1 PMOS l=1u w=2u
M56 SUM1 N021_1 0 0 NMOS l=1u w=1u
R15 VDD N002_1 0.001
R16 VDD N003_1 0.001
R17 VDD N004_1 0.001
R18 VDD N005_1 0.001
R19 VDD N006_1 0.001
R20 VDD N007_1 0.001
R21 VDD N013_1 0.001
R22 N012_1 VDD 0.001
R23 VDD N001_1 0.001
R24 VDD N019_1 0.001
R25 VDD N014_1 0.001
R26 VDD N015_1 0.001
R27 VDD N018_1 0.001
R28 VDD N020_1 0.001
C3 SUM1 0 1p
C4 C1 0 1p

* Bit 2
M57 N001_2 A2 N010_2 N001_2 PMOS l=1u w=4u
M58 N010_2 B2 N016_2 N012_2 PMOS l=1u w=4u
M59 N002_2 A2 N008_2 N002_2 PMOS l=1u w=4u
M60 N008_2 C1 N016_2 N013_2 PMOS l=1u w=4u
M61 N003_2 B2 N008_2 N003_2 PMOS l=1u w=4u
M62 VDD N016_2 C2 N020_2 PMOS l=1u w=2u
M63 N004_2 A2 N009_2 N004_2 PMOS l=1u w=4u
M64 N005_2 B2 N009_2 N005_2 PMOS l=1u w=4u
M65 N006_2 C1 N009_2 N006_2 PMOS l=1u w=4u
M66 N007_2 A2 N011_2 N007_2 PMOS l=1u w=8u
M67 N011_2 B2 N017_2 N015_2 PMOS l=1u w=8u
M68 N017_2 C1 N021_2 N018_2 PMOS l=1u w=8u
M69 N021_2 C1 N022_2 0 NMOS l=1u w=8u
M70 N022_2 B2 N026_2 0 NMOS l=1u w=8u
M71 N026_2 A2 0 0 NMOS l=1u w=8u
M72 N024_2 C1 0 0 NMOS l=1u w=2u
M73 N024_2 B2 0 0 NMOS l=1u w=2u
M74 N024_2 A2 0 0 NMOS l=1u w=2u
M75 N021_2 N016_2 N024_2 0 NMOS l=1u w=2u
M76 N023_2 B2 0 0 NMOS l=1u w=2u
M77 N023_2 A2 0 0 NMOS l=1u w=2u
M78 N025_2 A2 0 0 NMOS l=1u w=2u
M79 N016_2 B2 N025_2 0 NMOS l=1u w=2u
M80 N016_2 C1 N023_2 0 NMOS l=1u w=2u
M81 C2 N016_2 0 0 NMOS l=1u w=1u
M82 N009_2 N016_2 N021_2 N014_2 PMOS l=1u w=4u
M83 N019_2 N021_2 SUM2 N019_2 PMOS l=1u w=2u
M84 SUM2 N021_2 0 0 NMOS l=1u w=1u
R29 VDD N002_2 0.001
R30 VDD N003_2 0.001
R31 VDD N004_2 0.001
R32 VDD N005_2 0.001
R33 VDD N006_2 0.001
R34 VDD N007_2 0.001
R35 VDD N013_2 0.001
R36 N012_2 VDD 0.001
R37 VDD N001_2 0.001
R38 VDD N019_2 0.001
R39 VDD N014_2 0.001
R40 VDD N015_2 0.001
R41 VDD N018_2 0.001
R42 VDD N020_2 0.001
C5 SUM2 0 1p
C6 C2 0 1p

* Bit 3
M85 N001_3 A3 N010_3 N001_3 PMOS l=1u w=4u
M86 N010_3 B3 N016_3 N012_3 PMOS l=1u w=4u
M87 N002_3 A3 N008_3 N002_3 PMOS l=1u w=4u
M88 N008_3 C2 N016_3 N013_3 PMOS l=1u w=4u
M89 N003_3 B3 N008_3 N003_3 PMOS l=1u w=4u
M90 VDD N016_3 C3 N020_3 PMOS l=1u w=2u
M91 N004_3 A3 N009_3 N004_3 PMOS l=1u w=4u
M92 N005_3 B3 N009_3 N005_3 PMOS l=1u w=4u
M93 N006_3 C2 N009_3 N006_3 PMOS l=1u w=4u
M94 N007_3 A3 N011_3 N007_3 PMOS l=1u w=8u
M95 N011_3 B3 N017_3 N015_3 PMOS l=1u w=8u
M96 N017_3 C2 N021_3 N018_3 PMOS l=1u w=8u
M97 N021_3 C2 N022_3 0 NMOS l=1u w=8u
M98 N022_3 B3 N026_3 0 NMOS l=1u w=8u
M99 N026_3 A3 0 0 NMOS l=1u w=8u
M100 N024_3 C2 0 0 NMOS l=1u w=2u
M101 N024_3 B3 0 0 NMOS l=1u w=2u
M102 N024_3 A3 0 0 NMOS l=1u w=2u
M103 N021_3 N016_3 N024_3 0 NMOS l=1u w=2u
M104 N023_3 B3 0 0 NMOS l=1u w=2u
M105 N023_3 A3 0 0 NMOS l=1u w=2u
M106 N025_3 A3 0 0 NMOS l=1u w=2u
M107 N016_3 B3 N025_3 0 NMOS l=1u w=2u
M108 N016_3 C2 N023_3 0 NMOS l=1u w=2u
M109 C3 N016_3 0 0 NMOS l=1u w=1u
M110 N009_3 N016_3 N021_3 N014_3 PMOS l=1u w=4u
M111 N019_3 N021_3 SUM3 N019_3 PMOS l=1u w=2u
M112 SUM3 N021_3 0 0 NMOS l=1u w=1u
R43 VDD N002_3 0.001
R44 VDD N003_3 0.001
R45 VDD N004_3 0.001
R46 VDD N005_3 0.001
R47 VDD N006_3 0.001
R48 VDD N007_3 0.001
R49 VDD N013_3 0.001
R50 N012_3 VDD 0.001
R51 VDD N001_3 0.001
R52 VDD N019_3 0.001
R53 VDD N014_3 0.001
R54 VDD N015_3 0.001
R55 VDD N018_3 0.001
R56 VDD N020_3 0.001
C7 SUM3 0 1p
C8 C3 0 1p

* Bit 4
M113 N001_4 A4 N010_4 N001_4 PMOS l=1u w=4u
M114 N010_4 B4 N016_4 N012_4 PMOS l=1u w=4u
M115 N002_4 A4 N008_4 N002_4 PMOS l=1u w=4u
M116 N008_4 C3 N016_4 N013_4 PMOS l=1u w=4u
M117 N003_4 B4 N008_4 N003_4 PMOS l=1u w=4u
M118 VDD N016_4 C4 N020_4 PMOS l=1u w=2u
M119 N004_4 A4 N009_4 N004_4 PMOS l=1u w=4u
M120 N005_4 B4 N009_4 N005_4 PMOS l=1u w=4u
M121 N006_4 C3 N009_4 N006_4 PMOS l=1u w=4u
M122 N007_4 A4 N011_4 N007_4 PMOS l=1u w=8u
M123 N011_4 B4 N017_4 N015_4 PMOS l=1u w=8u
M124 N017_4 C3 N021_4 N018_4 PMOS l=1u w=8u
M125 N021_4 C3 N022_4 0 NMOS l=1u w=8u
M126 N022_4 B4 N026_4 0 NMOS l=1u w=8u
M127 N026_4 A4 0 0 NMOS l=1u w=8u
M128 N024_4 C3 0 0 NMOS l=1u w=2u
M129 N024_4 B4 0 0 NMOS l=1u w=2u
M130 N024_4 A4 0 0 NMOS l=1u w=2u
M131 N021_4 N016_4 N024_4 0 NMOS l=1u w=2u
M132 N023_4 B4 0 0 NMOS l=1u w=2u
M133 N023_4 A4 0 0 NMOS l=1u w=2u
M134 N025_4 A4 0 0 NMOS l=1u w=2u
M135 N016_4 B4 N025_4 0 NMOS l=1u w=2u
M136 N016_4 C3 N023_4 0 NMOS l=1u w=2u
M137 C4 N016_4 0 0 NMOS l=1u w=1u
M138 N009_4 N016_4 N021_4 N014_4 PMOS l=1u w=4u
M139 N019_4 N021_4 SUM4 N019_4 PMOS l=1u w=2u
M140 SUM4 N021_4 0 0 NMOS l=1u w=1u
R57 VDD N002_4 0.001
R58 VDD N003_4 0.001
R59 VDD N004_4 0.001
R60 VDD N005_4 0.001
R61 VDD N006_4 0.001
R62 VDD N007_4 0.001
R63 VDD N013_4 0.001
R64 N012_4 VDD 0.001
R65 VDD N001_4 0.001
R66 VDD N019_4 0.001
R67 VDD N014_4 0.001
R68 VDD N015_4 0.001
R69 VDD N018_4 0.001
R70 VDD N020_4 0.001
C9 SUM4 0 1p
C10 C4 0 1p

* Bit 5
M141 N001_5 A5 N010_5 N001_5 PMOS l=1u w=4u
M142 N010_5 B5 N016_5 N012_5 PMOS l=1u w=4u
M143 N002_5 A5 N008_5 N002_5 PMOS l=1u w=4u
M144 N008_5 C4 N016_5 N013_5 PMOS l=1u w=4u
M145 N003_5 B5 N008_5 N003_5 PMOS l=1u w=4u
M146 VDD N016_5 C5 N020_5 PMOS l=1u w=2u
M147 N004_5 A5 N009_5 N004_5 PMOS l=1u w=4u
M148 N005_5 B5 N009_5 N005_5 PMOS l=1u w=4u
M149 N006_5 C4 N009_5 N006_5 PMOS l=1u w=4u
M150 N007_5 A5 N011_5 N007_5 PMOS l=1u w=8u
M151 N011_5 B5 N017_5 N015_5 PMOS l=1u w=8u
M152 N017_5 C4 N021_5 N018_5 PMOS l=1u w=8u
M153 N021_5 C4 N022_5 0 NMOS l=1u w=8u
M154 N022_5 B5 N026_5 0 NMOS l=1u w=8u
M155 N026_5 A5 0 0 NMOS l=1u w=8u
M156 N024_5 C4 0 0 NMOS l=1u w=2u
M157 N024_5 B5 0 0 NMOS l=1u w=2u
M158 N024_5 A5 0 0 NMOS l=1u w=2u
M159 N021_5 N016_5 N024_5 0 NMOS l=1u w=2u
M160 N023_5 B5 0 0 NMOS l=1u w=2u
M161 N023_5 A5 0 0 NMOS l=1u w=2u
M162 N025_5 A5 0 0 NMOS l=1u w=2u
M163 N016_5 B5 N025_5 0 NMOS l=1u w=2u
M164 N016_5 C4 N023_5 0 NMOS l=1u w=2u
M165 C5 N016_5 0 0 NMOS l=1u w=1u
M166 N009_5 N016_5 N021_5 N014_5 PMOS l=1u w=4u
M167 N019_5 N021_5 SUM5 N019_5 PMOS l=1u w=2u
M168 SUM5 N021_5 0 0 NMOS l=1u w=1u
R71 VDD N002_5 0.001
R72 VDD N003_5 0.001
R73 VDD N004_5 0.001
R74 VDD N005_5 0.001
R75 VDD N006_5 0.001
R76 VDD N007_5 0.001
R77 VDD N013_5 0.001
R78 N012_5 VDD 0.001
R79 VDD N001_5 0.001
R80 VDD N019_5 0.001
R81 VDD N014_5 0.001
R82 VDD N015_5 0.001
R83 VDD N018_5 0.001
R84 VDD N020_5 0.001
C11 SUM5 0 1p
C12 C5 0 1p

* Bit 6
M169 N001_6 A6 N010_6 N001_6 PMOS l=1u w=4u
M170 N010_6 B6 N016_6 N012_6 PMOS l=1u w=4u
M171 N002_6 A6 N008_6 N002_6 PMOS l=1u w=4u
M172 N008_6 C5 N016_6 N013_6 PMOS l=1u w=4u
M173 N003_6 B6 N008_6 N003_6 PMOS l=1u w=4u
M174 VDD N016_6 C6 N020_6 PMOS l=1u w=2u
M175 N004_6 A6 N009_6 N004_6 PMOS l=1u w=4u
M176 N005_6 B6 N009_6 N005_6 PMOS l=1u w=4u
M177 N006_6 C5 N009_6 N006_6 PMOS l=1u w=4u
M178 N007_6 A6 N011_6 N007_6 PMOS l=1u w=8u
M179 N011_6 B6 N017_6 N015_6 PMOS l=1u w=8u
M180 N017_6 C5 N021_6 N018_6 PMOS l=1u w=8u
M181 N021_6 C5 N022_6 0 NMOS l=1u w=8u
M182 N022_6 B6 N026_6 0 NMOS l=1u w=8u
M183 N026_6 A6 0 0 NMOS l=1u w=8u
M184 N024_6 C5 0 0 NMOS l=1u w=2u
M185 N024_6 B6 0 0 NMOS l=1u w=2u
M186 N024_6 A6 0 0 NMOS l=1u w=2u
M187 N021_6 N016_6 N024_6 0 NMOS l=1u w=2u
M188 N023_6 B6 0 0 NMOS l=1u w=2u
M189 N023_6 A6 0 0 NMOS l=1u w=2u
M190 N025_6 A6 0 0 NMOS l=1u w=2u
M191 N016_6 B6 N025_6 0 NMOS l=1u w=2u
M192 N016_6 C5 N023_6 0 NMOS l=1u w=2u
M193 C6 N016_6 0 0 NMOS l=1u w=1u
M194 N009_6 N016_6 N021_6 N014_6 PMOS l=1u w=4u
M195 N019_6 N021_6 SUM6 N019_6 PMOS l=1u w=2u
M196 SUM6 N021_6 0 0 NMOS l=1u w=1u
R85 VDD N002_6 0.001
R86 VDD N003_6 0.001
R87 VDD N004_6 0.001
R88 VDD N005_6 0.001
R89 VDD N006_6 0.001
R90 VDD N007_6 0.001
R91 VDD N013_6 0.001
R92 N012_6 VDD 0.001
R93 VDD N001_6 0.001
R94 VDD N019_6 0.001
R95 VDD N014_6 0.001
R96 VDD N015_6 0.001
R97 VDD N018_6 0.001
R98 VDD N020_6 0.001
C13 SUM6 0 1p
C14 C6 0 1p

* Bit 7
M197 N001_7 A7 N010_7 N001_7 PMOS l=1u w=4u
M198 N010_7 B7 N016_7 N012_7 PMOS l=1u w=4u
M199 N002_7 A7 N008_7 N002_7 PMOS l=1u w=4u
M200 N008_7 C6 N016_7 N013_7 PMOS l=1u w=4u
M201 N003_7 B7 N008_7 N003_7 PMOS l=1u w=4u
M202 VDD N016_7 C7 N020_7 PMOS l=1u w=2u
M203 N004_7 A7 N009_7 N004_7 PMOS l=1u w=4u
M204 N005_7 B7 N009_7 N005_7 PMOS l=1u w=4u
M205 N006_7 C6 N009_7 N006_7 PMOS l=1u w=4u
M206 N007_7 A7 N011_7 N007_7 PMOS l=1u w=8u
M207 N011_7 B7 N017_7 N015_7 PMOS l=1u w=8u
M208 N017_7 C6 N021_7 N018_7 PMOS l=1u w=8u
M209 N021_7 C6 N022_7 0 NMOS l=1u w=8u
M210 N022_7 B7 N026_7 0 NMOS l=1u w=8u
M211 N026_7 A7 0 0 NMOS l=1u w=8u
M212 N024_7 C6 0 0 NMOS l=1u w=2u
M213 N024_7 B7 0 0 NMOS l=1u w=2u
M214 N024_7 A7 0 0 NMOS l=1u w=2u
M215 N021_7 N016_7 N024_7 0 NMOS l=1u w=2u
M216 N023_7 B7 0 0 NMOS l=1u w=2u
M217 N023_7 A7 0 0 NMOS l=1u w=2u
M218 N025_7 A7 0 0 NMOS l=1u w=2u
M219 N016_7 B7 N025_7 0 NMOS l=1u w=2u
M220 N016_7 C6 N023_7 0 NMOS l=1u w=2u
M221 C7 N016_7 0 0 NMOS l=1u w=1u
M222 N009_7 N016_7 N021_7 N014_7 PMOS l=1u w=4u
M223 N019_7 N021_7 SUM7 N019_7 PMOS l=1u w=2u
M224 SUM7 N021_7 0 0 NMOS l=1u w=1u
R99 VDD N002_7 0.001
R100 VDD N003_7 0.001
R101 VDD N004_7 0.001
R102 VDD N005_7 0.001
R103 VDD N006_7 0.001
R104 VDD N007_7 0.001
R105 VDD N013_7 0.001
R106 N012_7 VDD 0.001
R107 VDD N001_7 0.001
R108 VDD N019_7 0.001
R109 VDD N014_7 0.001
R110 VDD N015_7 0.001
R111 VDD N018_7 0.001
R112 VDD N020_7 0.001
C15 SUM7 0 1p
C16 C7 0 1p

* Bit 8
M225 N001_8 A8 N010_8 N001_8 PMOS l=1u w=4u
M226 N010_8 B8 N016_8 N012_8 PMOS l=1u w=4u
M227 N002_8 A8 N008_8 N002_8 PMOS l=1u w=4u
M228 N008_8 C7 N016_8 N013_8 PMOS l=1u w=4u
M229 N003_8 B8 N008_8 N003_8 PMOS l=1u w=4u
M230 VDD N016_8 C8 N020_8 PMOS l=1u w=2u
M231 N004_8 A8 N009_8 N004_8 PMOS l=1u w=4u
M232 N005_8 B8 N009_8 N005_8 PMOS l=1u w=4u
M233 N006_8 C7 N009_8 N006_8 PMOS l=1u w=4u
M234 N007_8 A8 N011_8 N007_8 PMOS l=1u w=8u
M235 N011_8 B8 N017_8 N015_8 PMOS l=1u w=8u
M236 N017_8 C7 N021_8 N018_8 PMOS l=1u w=8u
M237 N021_8 C7 N022_8 0 NMOS l=1u w=8u
M238 N022_8 B8 N026_8 0 NMOS l=1u w=8u
M239 N026_8 A8 0 0 NMOS l=1u w=8u
M240 N024_8 C7 0 0 NMOS l=1u w=2u
M241 N024_8 B8 0 0 NMOS l=1u w=2u
M242 N024_8 A8 0 0 NMOS l=1u w=2u
M243 N021_8 N016_8 N024_8 0 NMOS l=1u w=2u
M244 N023_8 B8 0 0 NMOS l=1u w=2u
M245 N023_8 A8 0 0 NMOS l=1u w=2u
M246 N025_8 A8 0 0 NMOS l=1u w=2u
M247 N016_8 B8 N025_8 0 NMOS l=1u w=2u
M248 N016_8 C7 N023_8 0 NMOS l=1u w=2u
M249 C8 N016_8 0 0 NMOS l=1u w=1u
M250 N009_8 N016_8 N021_8 N014_8 PMOS l=1u w=4u
M251 N019_8 N021_8 SUM8 N019_8 PMOS l=1u w=2u
M252 SUM8 N021_8 0 0 NMOS l=1u w=1u
R113 VDD N002_8 0.001
R114 VDD N003_8 0.001
R115 VDD N004_8 0.001
R116 VDD N005_8 0.001
R117 VDD N006_8 0.001
R118 VDD N007_8 0.001
R119 VDD N013_8 0.001
R120 N012_8 VDD 0.001
R121 VDD N001_8 0.001
R122 VDD N019_8 0.001
R123 VDD N014_8 0.001
R124 VDD N015_8 0.001
R125 VDD N018_8 0.001
R126 VDD N020_8 0.001
C17 SUM8 0 1p
C18 C8 0 1p

* Bit 9
M253 N001_9 A9 N010_9 N001_9 PMOS l=1u w=4u
M254 N010_9 B9 N016_9 N012_9 PMOS l=1u w=4u
M255 N002_9 A9 N008_9 N002_9 PMOS l=1u w=4u
M256 N008_9 C8 N016_9 N013_9 PMOS l=1u w=4u
M257 N003_9 B9 N008_9 N003_9 PMOS l=1u w=4u
M258 VDD N016_9 C9 N020_9 PMOS l=1u w=2u
M259 N004_9 A9 N009_9 N004_9 PMOS l=1u w=4u
M260 N005_9 B9 N009_9 N005_9 PMOS l=1u w=4u
M261 N006_9 C8 N009_9 N006_9 PMOS l=1u w=4u
M262 N007_9 A9 N011_9 N007_9 PMOS l=1u w=8u
M263 N011_9 B9 N017_9 N015_9 PMOS l=1u w=8u
M264 N017_9 C8 N021_9 N018_9 PMOS l=1u w=8u
M265 N021_9 C8 N022_9 0 NMOS l=1u w=8u
M266 N022_9 B9 N026_9 0 NMOS l=1u w=8u
M267 N026_9 A9 0 0 NMOS l=1u w=8u
M268 N024_9 C8 0 0 NMOS l=1u w=2u
M269 N024_9 B9 0 0 NMOS l=1u w=2u
M270 N024_9 A9 0 0 NMOS l=1u w=2u
M271 N021_9 N016_9 N024_9 0 NMOS l=1u w=2u
M272 N023_9 B9 0 0 NMOS l=1u w=2u
M273 N023_9 A9 0 0 NMOS l=1u w=2u
M274 N025_9 A9 0 0 NMOS l=1u w=2u
M275 N016_9 B9 N025_9 0 NMOS l=1u w=2u
M276 N016_9 C8 N023_9 0 NMOS l=1u w=2u
M277 C9 N016_9 0 0 NMOS l=1u w=1u
M278 N009_9 N016_9 N021_9 N014_9 PMOS l=1u w=4u
M279 N019_9 N021_9 SUM9 N019_9 PMOS l=1u w=2u
M280 SUM9 N021_9 0 0 NMOS l=1u w=1u
R127 VDD N002_9 0.001
R128 VDD N003_9 0.001
R129 VDD N004_9 0.001
R130 VDD N005_9 0.001
R131 VDD N006_9 0.001
R132 VDD N007_9 0.001
R133 VDD N013_9 0.001
R134 N012_9 VDD 0.001
R135 VDD N001_9 0.001
R136 VDD N019_9 0.001
R137 VDD N014_9 0.001
R138 VDD N015_9 0.001
R139 VDD N018_9 0.001
R140 VDD N020_9 0.001
C19 SUM9 0 1p
C20 C9 0 1p

* Bit 10
M281 N001_10 A10 N010_10 N001_10 PMOS l=1u w=4u
M282 N010_10 B10 N016_10 N012_10 PMOS l=1u w=4u
M283 N002_10 A10 N008_10 N002_10 PMOS l=1u w=4u
M284 N008_10 C9 N016_10 N013_10 PMOS l=1u w=4u
M285 N003_10 B10 N008_10 N003_10 PMOS l=1u w=4u
M286 VDD N016_10 C10 N020_10 PMOS l=1u w=2u
M287 N004_10 A10 N009_10 N004_10 PMOS l=1u w=4u
M288 N005_10 B10 N009_10 N005_10 PMOS l=1u w=4u
M289 N006_10 C9 N009_10 N006_10 PMOS l=1u w=4u
M290 N007_10 A10 N011_10 N007_10 PMOS l=1u w=8u
M291 N011_10 B10 N017_10 N015_10 PMOS l=1u w=8u
M292 N017_10 C9 N021_10 N018_10 PMOS l=1u w=8u
M293 N021_10 C9 N022_10 0 NMOS l=1u w=8u
M294 N022_10 B10 N026_10 0 NMOS l=1u w=8u
M295 N026_10 A10 0 0 NMOS l=1u w=8u
M296 N024_10 C9 0 0 NMOS l=1u w=2u
M297 N024_10 B10 0 0 NMOS l=1u w=2u
M298 N024_10 A10 0 0 NMOS l=1u w=2u
M299 N021_10 N016_10 N024_10 0 NMOS l=1u w=2u
M300 N023_10 B10 0 0 NMOS l=1u w=2u
M301 N023_10 A10 0 0 NMOS l=1u w=2u
M302 N025_10 A10 0 0 NMOS l=1u w=2u
M303 N016_10 B10 N025_10 0 NMOS l=1u w=2u
M304 N016_10 C9 N023_10 0 NMOS l=1u w=2u
M305 C10 N016_10 0 0 NMOS l=1u w=1u
M306 N009_10 N016_10 N021_10 N014_10 PMOS l=1u w=4u
M307 N019_10 N021_10 SUM10 N019_10 PMOS l=1u w=2u
M308 SUM10 N021_10 0 0 NMOS l=1u w=1u
R141 VDD N002_10 0.001
R142 VDD N003_10 0.001
R143 VDD N004_10 0.001
R144 VDD N005_10 0.001
R145 VDD N006_10 0.001
R146 VDD N007_10 0.001
R147 VDD N013_10 0.001
R148 N012_10 VDD 0.001
R149 VDD N001_10 0.001
R150 VDD N019_10 0.001
R151 VDD N014_10 0.001
R152 VDD N015_10 0.001
R153 VDD N018_10 0.001
R154 VDD N020_10 0.001
C21 SUM10 0 1p
C22 C10 0 1p

* Bit 11
M309 N001_11 A11 N010_11 N001_11 PMOS l=1u w=4u
M310 N010_11 B11 N016_11 N012_11 PMOS l=1u w=4u
M311 N002_11 A11 N008_11 N002_11 PMOS l=1u w=4u
M312 N008_11 C10 N016_11 N013_11 PMOS l=1u w=4u
M313 N003_11 B11 N008_11 N003_11 PMOS l=1u w=4u
M314 VDD N016_11 C11 N020_11 PMOS l=1u w=2u
M315 N004_11 A11 N009_11 N004_11 PMOS l=1u w=4u
M316 N005_11 B11 N009_11 N005_11 PMOS l=1u w=4u
M317 N006_11 C10 N009_11 N006_11 PMOS l=1u w=4u
M318 N007_11 A11 N011_11 N007_11 PMOS l=1u w=8u
M319 N011_11 B11 N017_11 N015_11 PMOS l=1u w=8u
M320 N017_11 C10 N021_11 N018_11 PMOS l=1u w=8u
M321 N021_11 C10 N022_11 0 NMOS l=1u w=8u
M322 N022_11 B11 N026_11 0 NMOS l=1u w=8u
M323 N026_11 A11 0 0 NMOS l=1u w=8u
M324 N024_11 C10 0 0 NMOS l=1u w=2u
M325 N024_11 B11 0 0 NMOS l=1u w=2u
M326 N024_11 A11 0 0 NMOS l=1u w=2u
M327 N021_11 N016_11 N024_11 0 NMOS l=1u w=2u
M328 N023_11 B11 0 0 NMOS l=1u w=2u
M329 N023_11 A11 0 0 NMOS l=1u w=2u
M330 N025_11 A11 0 0 NMOS l=1u w=2u
M331 N016_11 B11 N025_11 0 NMOS l=1u w=2u
M332 N016_11 C10 N023_11 0 NMOS l=1u w=2u
M333 C11 N016_11 0 0 NMOS l=1u w=1u
M334 N009_11 N016_11 N021_11 N014_11 PMOS l=1u w=4u
M335 N019_11 N021_11 SUM11 N019_11 PMOS l=1u w=2u
M336 SUM11 N021_11 0 0 NMOS l=1u w=1u
R155 VDD N002_11 0.001
R156 VDD N003_11 0.001
R157 VDD N004_11 0.001
R158 VDD N005_11 0.001
R159 VDD N006_11 0.001
R160 VDD N007_11 0.001
R161 VDD N013_11 0.001
R162 N012_11 VDD 0.001
R163 VDD N001_11 0.001
R164 VDD N019_11 0.001
R165 VDD N014_11 0.001
R166 VDD N015_11 0.001
R167 VDD N018_11 0.001
R168 VDD N020_11 0.001
C23 SUM11 0 1p
C24 C11 0 1p

* Bit 12
M337 N001_12 A12 N010_12 N001_12 PMOS l=1u w=4u
M338 N010_12 B12 N016_12 N012_12 PMOS l=1u w=4u
M339 N002_12 A12 N008_12 N002_12 PMOS l=1u w=4u
M340 N008_12 C11 N016_12 N013_12 PMOS l=1u w=4u
M341 N003_12 B12 N008_12 N003_12 PMOS l=1u w=4u
M342 VDD N016_12 C12 N020_12 PMOS l=1u w=2u
M343 N004_12 A12 N009_12 N004_12 PMOS l=1u w=4u
M344 N005_12 B12 N009_12 N005_12 PMOS l=1u w=4u
M345 N006_12 C11 N009_12 N006_12 PMOS l=1u w=4u
M346 N007_12 A12 N011_12 N007_12 PMOS l=1u w=8u
M347 N011_12 B12 N017_12 N015_12 PMOS l=1u w=8u
M348 N017_12 C11 N021_12 N018_12 PMOS l=1u w=8u
M349 N021_12 C11 N022_12 0 NMOS l=1u w=8u
M350 N022_12 B12 N026_12 0 NMOS l=1u w=8u
M351 N026_12 A12 0 0 NMOS l=1u w=8u
M352 N024_12 C11 0 0 NMOS l=1u w=2u
M353 N024_12 B12 0 0 NMOS l=1u w=2u
M354 N024_12 A12 0 0 NMOS l=1u w=2u
M355 N021_12 N016_12 N024_12 0 NMOS l=1u w=2u
M356 N023_12 B12 0 0 NMOS l=1u w=2u
M357 N023_12 A12 0 0 NMOS l=1u w=2u
M358 N025_12 A12 0 0 NMOS l=1u w=2u
M359 N016_12 B12 N025_12 0 NMOS l=1u w=2u
M360 N016_12 C11 N023_12 0 NMOS l=1u w=2u
M361 C12 N016_12 0 0 NMOS l=1u w=1u
M362 N009_12 N016_12 N021_12 N014_12 PMOS l=1u w=4u
M363 N019_12 N021_12 SUM12 N019_12 PMOS l=1u w=2u
M364 SUM12 N021_12 0 0 NMOS l=1u w=1u
R169 VDD N002_12 0.001
R170 VDD N003_12 0.001
R171 VDD N004_12 0.001
R172 VDD N005_12 0.001
R173 VDD N006_12 0.001
R174 VDD N007_12 0.001
R175 VDD N013_12 0.001
R176 N012_12 VDD 0.001
R177 VDD N001_12 0.001
R178 VDD N019_12 0.001
R179 VDD N014_12 0.001
R180 VDD N015_12 0.001
R181 VDD N018_12 0.001
R182 VDD N020_12 0.001
C25 SUM12 0 1p
C26 C12 0 1p

* Bit 13
M365 N001_13 A13 N010_13 N001_13 PMOS l=1u w=4u
M366 N010_13 B13 N016_13 N012_13 PMOS l=1u w=4u
M367 N002_13 A13 N008_13 N002_13 PMOS l=1u w=4u
M368 N008_13 C12 N016_13 N013_13 PMOS l=1u w=4u
M369 N003_13 B13 N008_13 N003_13 PMOS l=1u w=4u
M370 VDD N016_13 C13 N020_13 PMOS l=1u w=2u
M371 N004_13 A13 N009_13 N004_13 PMOS l=1u w=4u
M372 N005_13 B13 N009_13 N005_13 PMOS l=1u w=4u
M373 N006_13 C12 N009_13 N006_13 PMOS l=1u w=4u
M374 N007_13 A13 N011_13 N007_13 PMOS l=1u w=8u
M375 N011_13 B13 N017_13 N015_13 PMOS l=1u w=8u
M376 N017_13 C12 N021_13 N018_13 PMOS l=1u w=8u
M377 N021_13 C12 N022_13 0 NMOS l=1u w=8u
M378 N022_13 B13 N026_13 0 NMOS l=1u w=8u
M379 N026_13 A13 0 0 NMOS l=1u w=8u
M380 N024_13 C12 0 0 NMOS l=1u w=2u
M381 N024_13 B13 0 0 NMOS l=1u w=2u
M382 N024_13 A13 0 0 NMOS l=1u w=2u
M383 N021_13 N016_13 N024_13 0 NMOS l=1u w=2u
M384 N023_13 B13 0 0 NMOS l=1u w=2u
M385 N023_13 A13 0 0 NMOS l=1u w=2u
M386 N025_13 A13 0 0 NMOS l=1u w=2u
M387 N016_13 B13 N025_13 0 NMOS l=1u w=2u
M388 N016_13 C12 N023_13 0 NMOS l=1u w=2u
M389 C13 N016_13 0 0 NMOS l=1u w=1u
M390 N009_13 N016_13 N021_13 N014_13 PMOS l=1u w=4u
M391 N019_13 N021_13 SUM13 N019_13 PMOS l=1u w=2u
M392 SUM13 N021_13 0 0 NMOS l=1u w=1u
R183 VDD N002_13 0.001
R184 VDD N003_13 0.001
R185 VDD N004_13 0.001
R186 VDD N005_13 0.001
R187 VDD N006_13 0.001
R188 VDD N007_13 0.001
R189 VDD N013_13 0.001
R190 N012_13 VDD 0.001
R191 VDD N001_13 0.001
R192 VDD N019_13 0.001
R193 VDD N014_13 0.001
R194 VDD N015_13 0.001
R195 VDD N018_13 0.001
R196 VDD N020_13 0.001
C27 SUM13 0 1p
C28 C13 0 1p

* Bit 14
M393 N001_14 A14 N010_14 N001_14 PMOS l=1u w=4u
M394 N010_14 B14 N016_14 N012_14 PMOS l=1u w=4u
M395 N002_14 A14 N008_14 N002_14 PMOS l=1u w=4u
M396 N008_14 C13 N016_14 N013_14 PMOS l=1u w=4u
M397 N003_14 B14 N008_14 N003_14 PMOS l=1u w=4u
M398 VDD N016_14 C14 N020_14 PMOS l=1u w=2u
M399 N004_14 A14 N009_14 N004_14 PMOS l=1u w=4u
M400 N005_14 B14 N009_14 N005_14 PMOS l=1u w=4u
M401 N006_14 C13 N009_14 N006_14 PMOS l=1u w=4u
M402 N007_14 A14 N011_14 N007_14 PMOS l=1u w=8u
M403 N011_14 B14 N017_14 N015_14 PMOS l=1u w=8u
M404 N017_14 C13 N021_14 N018_14 PMOS l=1u w=8u
M405 N021_14 C13 N022_14 0 NMOS l=1u w=8u
M406 N022_14 B14 N026_14 0 NMOS l=1u w=8u
M407 N026_14 A14 0 0 NMOS l=1u w=8u
M408 N024_14 C13 0 0 NMOS l=1u w=2u
M409 N024_14 B14 0 0 NMOS l=1u w=2u
M410 N024_14 A14 0 0 NMOS l=1u w=2u
M411 N021_14 N016_14 N024_14 0 NMOS l=1u w=2u
M412 N023_14 B14 0 0 NMOS l=1u w=2u
M413 N023_14 A14 0 0 NMOS l=1u w=2u
M414 N025_14 A14 0 0 NMOS l=1u w=2u
M415 N016_14 B14 N025_14 0 NMOS l=1u w=2u
M416 N016_14 C13 N023_14 0 NMOS l=1u w=2u
M417 C14 N016_14 0 0 NMOS l=1u w=1u
M418 N009_14 N016_14 N021_14 N014_14 PMOS l=1u w=4u
M419 N019_14 N021_14 SUM14 N019_14 PMOS l=1u w=2u
M420 SUM14 N021_14 0 0 NMOS l=1u w=1u
R197 VDD N002_14 0.001
R198 VDD N003_14 0.001
R199 VDD N004_14 0.001
R200 VDD N005_14 0.001
R201 VDD N006_14 0.001
R202 VDD N007_14 0.001
R203 VDD N013_14 0.001
R204 N012_14 VDD 0.001
R205 VDD N001_14 0.001
R206 VDD N019_14 0.001
R207 VDD N014_14 0.001
R208 VDD N015_14 0.001
R209 VDD N018_14 0.001
R210 VDD N020_14 0.001
C29 SUM14 0 1p
C30 C14 0 1p

* Bit 15
M421 N001_15 A15 N010_15 N001_15 PMOS l=1u w=4u
M422 N010_15 B15 N016_15 N012_15 PMOS l=1u w=4u
M423 N002_15 A15 N008_15 N002_15 PMOS l=1u w=4u
M424 N008_15 C14 N016_15 N013_15 PMOS l=1u w=4u
M425 N003_15 B15 N008_15 N003_15 PMOS l=1u w=4u
M426 VDD N016_15 C15 N020_15 PMOS l=1u w=2u
M427 N004_15 A15 N009_15 N004_15 PMOS l=1u w=4u
M428 N005_15 B15 N009_15 N005_15 PMOS l=1u w=4u
M429 N006_15 C14 N009_15 N006_15 PMOS l=1u w=4u
M430 N007_15 A15 N011_15 N007_15 PMOS l=1u w=8u
M431 N011_15 B15 N017_15 N015_15 PMOS l=1u w=8u
M432 N017_15 C14 N021_15 N018_15 PMOS l=1u w=8u
M433 N021_15 C14 N022_15 0 NMOS l=1u w=8u
M434 N022_15 B15 N026_15 0 NMOS l=1u w=8u
M435 N026_15 A15 0 0 NMOS l=1u w=8u
M436 N024_15 C14 0 0 NMOS l=1u w=2u
M437 N024_15 B15 0 0 NMOS l=1u w=2u
M438 N024_15 A15 0 0 NMOS l=1u w=2u
M439 N021_15 N016_15 N024_15 0 NMOS l=1u w=2u
M440 N023_15 B15 0 0 NMOS l=1u w=2u
M441 N023_15 A15 0 0 NMOS l=1u w=2u
M442 N025_15 A15 0 0 NMOS l=1u w=2u
M443 N016_15 B15 N025_15 0 NMOS l=1u w=2u
M444 N016_15 C14 N023_15 0 NMOS l=1u w=2u
M445 C15 N016_15 0 0 NMOS l=1u w=1u
M446 N009_15 N016_15 N021_15 N014_15 PMOS l=1u w=4u
M447 N019_15 N021_15 SUM15 N019_15 PMOS l=1u w=2u
M448 SUM15 N021_15 0 0 NMOS l=1u w=1u
R211 VDD N002_15 0.001
R212 VDD N003_15 0.001
R213 VDD N004_15 0.001
R214 VDD N005_15 0.001
R215 VDD N006_15 0.001
R216 VDD N007_15 0.001
R217 VDD N013_15 0.001
R218 N012_15 VDD 0.001
R219 VDD N001_15 0.001
R220 VDD N019_15 0.001
R221 VDD N014_15 0.001
R222 VDD N015_15 0.001
R223 VDD N018_15 0.001
R224 VDD N020_15 0.001
C31 SUM15 0 1p
C32 C15 0 1p

* Bit 16
M449 N001_16 A16 N010_16 N001_16 PMOS l=1u w=4u
M450 N010_16 B16 N016_16 N012_16 PMOS l=1u w=4u
M451 N002_16 A16 N008_16 N002_16 PMOS l=1u w=4u
M452 N008_16 C15 N016_16 N013_16 PMOS l=1u w=4u
M453 N003_16 B16 N008_16 N003_16 PMOS l=1u w=4u
M454 VDD N016_16 C16 N020_16 PMOS l=1u w=2u
M455 N004_16 A16 N009_16 N004_16 PMOS l=1u w=4u
M456 N005_16 B16 N009_16 N005_16 PMOS l=1u w=4u
M457 N006_16 C15 N009_16 N006_16 PMOS l=1u w=4u
M458 N007_16 A16 N011_16 N007_16 PMOS l=1u w=8u
M459 N011_16 B16 N017_16 N015_16 PMOS l=1u w=8u
M460 N017_16 C15 N021_16 N018_16 PMOS l=1u w=8u
M461 N021_16 C15 N022_16 0 NMOS l=1u w=8u
M462 N022_16 B16 N026_16 0 NMOS l=1u w=8u
M463 N026_16 A16 0 0 NMOS l=1u w=8u
M464 N024_16 C15 0 0 NMOS l=1u w=2u
M465 N024_16 B16 0 0 NMOS l=1u w=2u
M466 N024_16 A16 0 0 NMOS l=1u w=2u
M467 N021_16 N016_16 N024_16 0 NMOS l=1u w=2u
M468 N023_16 B16 0 0 NMOS l=1u w=2u
M469 N023_16 A16 0 0 NMOS l=1u w=2u
M470 N025_16 A16 0 0 NMOS l=1u w=2u
M471 N016_16 B16 N025_16 0 NMOS l=1u w=2u
M472 N016_16 C15 N023_16 0 NMOS l=1u w=2u
M473 C16 N016_16 0 0 NMOS l=1u w=1u
M474 N009_16 N016_16 N021_16 N014_16 PMOS l=1u w=4u
M475 N019_16 N021_16 SUM16 N019_16 PMOS l=1u w=2u
M476 SUM16 N021_16 0 0 NMOS l=1u w=1u
R225 VDD N002_16 0.001
R226 VDD N003_16 0.001
R227 VDD N004_16 0.001
R228 VDD N005_16 0.001
R229 VDD N006_16 0.001
R230 VDD N007_16 0.001
R231 VDD N013_16 0.001
R232 N012_16 VDD 0.001
R233 VDD N001_16 0.001
R234 VDD N019_16 0.001
R235 VDD N014_16 0.001
R236 VDD N015_16 0.001
R237 VDD N018_16 0.001
R238 VDD N020_16 0.001
C33 SUM16 0 1p
C34 C16 0 1p

* Bit 17
M477 N001_17 A17 N010_17 N001_17 PMOS l=1u w=4u
M478 N010_17 B17 N016_17 N012_17 PMOS l=1u w=4u
M479 N002_17 A17 N008_17 N002_17 PMOS l=1u w=4u
M480 N008_17 C16 N016_17 N013_17 PMOS l=1u w=4u
M481 N003_17 B17 N008_17 N003_17 PMOS l=1u w=4u
M482 VDD N016_17 C17 N020_17 PMOS l=1u w=2u
M483 N004_17 A17 N009_17 N004_17 PMOS l=1u w=4u
M484 N005_17 B17 N009_17 N005_17 PMOS l=1u w=4u
M485 N006_17 C16 N009_17 N006_17 PMOS l=1u w=4u
M486 N007_17 A17 N011_17 N007_17 PMOS l=1u w=8u
M487 N011_17 B17 N017_17 N015_17 PMOS l=1u w=8u
M488 N017_17 C16 N021_17 N018_17 PMOS l=1u w=8u
M489 N021_17 C16 N022_17 0 NMOS l=1u w=8u
M490 N022_17 B17 N026_17 0 NMOS l=1u w=8u
M491 N026_17 A17 0 0 NMOS l=1u w=8u
M492 N024_17 C16 0 0 NMOS l=1u w=2u
M493 N024_17 B17 0 0 NMOS l=1u w=2u
M494 N024_17 A17 0 0 NMOS l=1u w=2u
M495 N021_17 N016_17 N024_17 0 NMOS l=1u w=2u
M496 N023_17 B17 0 0 NMOS l=1u w=2u
M497 N023_17 A17 0 0 NMOS l=1u w=2u
M498 N025_17 A17 0 0 NMOS l=1u w=2u
M499 N016_17 B17 N025_17 0 NMOS l=1u w=2u
M500 N016_17 C16 N023_17 0 NMOS l=1u w=2u
M501 C17 N016_17 0 0 NMOS l=1u w=1u
M502 N009_17 N016_17 N021_17 N014_17 PMOS l=1u w=4u
M503 N019_17 N021_17 SUM17 N019_17 PMOS l=1u w=2u
M504 SUM17 N021_17 0 0 NMOS l=1u w=1u
R239 VDD N002_17 0.001
R240 VDD N003_17 0.001
R241 VDD N004_17 0.001
R242 VDD N005_17 0.001
R243 VDD N006_17 0.001
R244 VDD N007_17 0.001
R245 VDD N013_17 0.001
R246 N012_17 VDD 0.001
R247 VDD N001_17 0.001
R248 VDD N019_17 0.001
R249 VDD N014_17 0.001
R250 VDD N015_17 0.001
R251 VDD N018_17 0.001
R252 VDD N020_17 0.001
C35 SUM17 0 1p
C36 C17 0 1p

* Bit 18
M505 N001_18 A18 N010_18 N001_18 PMOS l=1u w=4u
M506 N010_18 B18 N016_18 N012_18 PMOS l=1u w=4u
M507 N002_18 A18 N008_18 N002_18 PMOS l=1u w=4u
M508 N008_18 C17 N016_18 N013_18 PMOS l=1u w=4u
M509 N003_18 B18 N008_18 N003_18 PMOS l=1u w=4u
M510 VDD N016_18 C18 N020_18 PMOS l=1u w=2u
M511 N004_18 A18 N009_18 N004_18 PMOS l=1u w=4u
M512 N005_18 B18 N009_18 N005_18 PMOS l=1u w=4u
M513 N006_18 C17 N009_18 N006_18 PMOS l=1u w=4u
M514 N007_18 A18 N011_18 N007_18 PMOS l=1u w=8u
M515 N011_18 B18 N017_18 N015_18 PMOS l=1u w=8u
M516 N017_18 C17 N021_18 N018_18 PMOS l=1u w=8u
M517 N021_18 C17 N022_18 0 NMOS l=1u w=8u
M518 N022_18 B18 N026_18 0 NMOS l=1u w=8u
M519 N026_18 A18 0 0 NMOS l=1u w=8u
M520 N024_18 C17 0 0 NMOS l=1u w=2u
M521 N024_18 B18 0 0 NMOS l=1u w=2u
M522 N024_18 A18 0 0 NMOS l=1u w=2u
M523 N021_18 N016_18 N024_18 0 NMOS l=1u w=2u
M524 N023_18 B18 0 0 NMOS l=1u w=2u
M525 N023_18 A18 0 0 NMOS l=1u w=2u
M526 N025_18 A18 0 0 NMOS l=1u w=2u
M527 N016_18 B18 N025_18 0 NMOS l=1u w=2u
M528 N016_18 C17 N023_18 0 NMOS l=1u w=2u
M529 C18 N016_18 0 0 NMOS l=1u w=1u
M530 N009_18 N016_18 N021_18 N014_18 PMOS l=1u w=4u
M531 N019_18 N021_18 SUM18 N019_18 PMOS l=1u w=2u
M532 SUM18 N021_18 0 0 NMOS l=1u w=1u
R253 VDD N002_18 0.001
R254 VDD N003_18 0.001
R255 VDD N004_18 0.001
R256 VDD N005_18 0.001
R257 VDD N006_18 0.001
R258 VDD N007_18 0.001
R259 VDD N013_18 0.001
R260 N012_18 VDD 0.001
R261 VDD N001_18 0.001
R262 VDD N019_18 0.001
R263 VDD N014_18 0.001
R264 VDD N015_18 0.001
R265 VDD N018_18 0.001
R266 VDD N020_18 0.001
C37 SUM18 0 1p
C38 C18 0 1p

* Bit 19
M533 N001_19 A19 N010_19 N001_19 PMOS l=1u w=4u
M534 N010_19 B19 N016_19 N012_19 PMOS l=1u w=4u
M535 N002_19 A19 N008_19 N002_19 PMOS l=1u w=4u
M536 N008_19 C18 N016_19 N013_19 PMOS l=1u w=4u
M537 N003_19 B19 N008_19 N003_19 PMOS l=1u w=4u
M538 VDD N016_19 C19 N020_19 PMOS l=1u w=2u
M539 N004_19 A19 N009_19 N004_19 PMOS l=1u w=4u
M540 N005_19 B19 N009_19 N005_19 PMOS l=1u w=4u
M541 N006_19 C18 N009_19 N006_19 PMOS l=1u w=4u
M542 N007_19 A19 N011_19 N007_19 PMOS l=1u w=8u
M543 N011_19 B19 N017_19 N015_19 PMOS l=1u w=8u
M544 N017_19 C18 N021_19 N018_19 PMOS l=1u w=8u
M545 N021_19 C18 N022_19 0 NMOS l=1u w=8u
M546 N022_19 B19 N026_19 0 NMOS l=1u w=8u
M547 N026_19 A19 0 0 NMOS l=1u w=8u
M548 N024_19 C18 0 0 NMOS l=1u w=2u
M549 N024_19 B19 0 0 NMOS l=1u w=2u
M550 N024_19 A19 0 0 NMOS l=1u w=2u
M551 N021_19 N016_19 N024_19 0 NMOS l=1u w=2u
M552 N023_19 B19 0 0 NMOS l=1u w=2u
M553 N023_19 A19 0 0 NMOS l=1u w=2u
M554 N025_19 A19 0 0 NMOS l=1u w=2u
M555 N016_19 B19 N025_19 0 NMOS l=1u w=2u
M556 N016_19 C18 N023_19 0 NMOS l=1u w=2u
M557 C19 N016_19 0 0 NMOS l=1u w=1u
M558 N009_19 N016_19 N021_19 N014_19 PMOS l=1u w=4u
M559 N019_19 N021_19 SUM19 N019_19 PMOS l=1u w=2u
M560 SUM19 N021_19 0 0 NMOS l=1u w=1u
R267 VDD N002_19 0.001
R268 VDD N003_19 0.001
R269 VDD N004_19 0.001
R270 VDD N005_19 0.001
R271 VDD N006_19 0.001
R272 VDD N007_19 0.001
R273 VDD N013_19 0.001
R274 N012_19 VDD 0.001
R275 VDD N001_19 0.001
R276 VDD N019_19 0.001
R277 VDD N014_19 0.001
R278 VDD N015_19 0.001
R279 VDD N018_19 0.001
R280 VDD N020_19 0.001
C39 SUM19 0 1p
C40 C19 0 1p

* Bit 20
M561 N001_20 A20 N010_20 N001_20 PMOS l=1u w=4u
M562 N010_20 B20 N016_20 N012_20 PMOS l=1u w=4u
M563 N002_20 A20 N008_20 N002_20 PMOS l=1u w=4u
M564 N008_20 C19 N016_20 N013_20 PMOS l=1u w=4u
M565 N003_20 B20 N008_20 N003_20 PMOS l=1u w=4u
M566 VDD N016_20 C20 N020_20 PMOS l=1u w=2u
M567 N004_20 A20 N009_20 N004_20 PMOS l=1u w=4u
M568 N005_20 B20 N009_20 N005_20 PMOS l=1u w=4u
M569 N006_20 C19 N009_20 N006_20 PMOS l=1u w=4u
M570 N007_20 A20 N011_20 N007_20 PMOS l=1u w=8u
M571 N011_20 B20 N017_20 N015_20 PMOS l=1u w=8u
M572 N017_20 C19 N021_20 N018_20 PMOS l=1u w=8u
M573 N021_20 C19 N022_20 0 NMOS l=1u w=8u
M574 N022_20 B20 N026_20 0 NMOS l=1u w=8u
M575 N026_20 A20 0 0 NMOS l=1u w=8u
M576 N024_20 C19 0 0 NMOS l=1u w=2u
M577 N024_20 B20 0 0 NMOS l=1u w=2u
M578 N024_20 A20 0 0 NMOS l=1u w=2u
M579 N021_20 N016_20 N024_20 0 NMOS l=1u w=2u
M580 N023_20 B20 0 0 NMOS l=1u w=2u
M581 N023_20 A20 0 0 NMOS l=1u w=2u
M582 N025_20 A20 0 0 NMOS l=1u w=2u
M583 N016_20 B20 N025_20 0 NMOS l=1u w=2u
M584 N016_20 C19 N023_20 0 NMOS l=1u w=2u
M585 C20 N016_20 0 0 NMOS l=1u w=1u
M586 N009_20 N016_20 N021_20 N014_20 PMOS l=1u w=4u
M587 N019_20 N021_20 SUM20 N019_20 PMOS l=1u w=2u
M588 SUM20 N021_20 0 0 NMOS l=1u w=1u
R281 VDD N002_20 0.001
R282 VDD N003_20 0.001
R283 VDD N004_20 0.001
R284 VDD N005_20 0.001
R285 VDD N006_20 0.001
R286 VDD N007_20 0.001
R287 VDD N013_20 0.001
R288 N012_20 VDD 0.001
R289 VDD N001_20 0.001
R290 VDD N019_20 0.001
R291 VDD N014_20 0.001
R292 VDD N015_20 0.001
R293 VDD N018_20 0.001
R294 VDD N020_20 0.001
C41 SUM20 0 1p
C42 C20 0 1p

* Bit 21
M589 N001_21 A21 N010_21 N001_21 PMOS l=1u w=4u
M590 N010_21 B21 N016_21 N012_21 PMOS l=1u w=4u
M591 N002_21 A21 N008_21 N002_21 PMOS l=1u w=4u
M592 N008_21 C20 N016_21 N013_21 PMOS l=1u w=4u
M593 N003_21 B21 N008_21 N003_21 PMOS l=1u w=4u
M594 VDD N016_21 C21 N020_21 PMOS l=1u w=2u
M595 N004_21 A21 N009_21 N004_21 PMOS l=1u w=4u
M596 N005_21 B21 N009_21 N005_21 PMOS l=1u w=4u
M597 N006_21 C20 N009_21 N006_21 PMOS l=1u w=4u
M598 N007_21 A21 N011_21 N007_21 PMOS l=1u w=8u
M599 N011_21 B21 N017_21 N015_21 PMOS l=1u w=8u
M600 N017_21 C20 N021_21 N018_21 PMOS l=1u w=8u
M601 N021_21 C20 N022_21 0 NMOS l=1u w=8u
M602 N022_21 B21 N026_21 0 NMOS l=1u w=8u
M603 N026_21 A21 0 0 NMOS l=1u w=8u
M604 N024_21 C20 0 0 NMOS l=1u w=2u
M605 N024_21 B21 0 0 NMOS l=1u w=2u
M606 N024_21 A21 0 0 NMOS l=1u w=2u
M607 N021_21 N016_21 N024_21 0 NMOS l=1u w=2u
M608 N023_21 B21 0 0 NMOS l=1u w=2u
M609 N023_21 A21 0 0 NMOS l=1u w=2u
M610 N025_21 A21 0 0 NMOS l=1u w=2u
M611 N016_21 B21 N025_21 0 NMOS l=1u w=2u
M612 N016_21 C20 N023_21 0 NMOS l=1u w=2u
M613 C21 N016_21 0 0 NMOS l=1u w=1u
M614 N009_21 N016_21 N021_21 N014_21 PMOS l=1u w=4u
M615 N019_21 N021_21 SUM21 N019_21 PMOS l=1u w=2u
M616 SUM21 N021_21 0 0 NMOS l=1u w=1u
R295 VDD N002_21 0.001
R296 VDD N003_21 0.001
R297 VDD N004_21 0.001
R298 VDD N005_21 0.001
R299 VDD N006_21 0.001
R300 VDD N007_21 0.001
R301 VDD N013_21 0.001
R302 N012_21 VDD 0.001
R303 VDD N001_21 0.001
R304 VDD N019_21 0.001
R305 VDD N014_21 0.001
R306 VDD N015_21 0.001
R307 VDD N018_21 0.001
R308 VDD N020_21 0.001
C43 SUM21 0 1p
C44 C21 0 1p

* Bit 22
M617 N001_22 A22 N010_22 N001_22 PMOS l=1u w=4u
M618 N010_22 B22 N016_22 N012_22 PMOS l=1u w=4u
M619 N002_22 A22 N008_22 N002_22 PMOS l=1u w=4u
M620 N008_22 C21 N016_22 N013_22 PMOS l=1u w=4u
M621 N003_22 B22 N008_22 N003_22 PMOS l=1u w=4u
M622 VDD N016_22 C22 N020_22 PMOS l=1u w=2u
M623 N004_22 A22 N009_22 N004_22 PMOS l=1u w=4u
M624 N005_22 B22 N009_22 N005_22 PMOS l=1u w=4u
M625 N006_22 C21 N009_22 N006_22 PMOS l=1u w=4u
M626 N007_22 A22 N011_22 N007_22 PMOS l=1u w=8u
M627 N011_22 B22 N017_22 N015_22 PMOS l=1u w=8u
M628 N017_22 C21 N021_22 N018_22 PMOS l=1u w=8u
M629 N021_22 C21 N022_22 0 NMOS l=1u w=8u
M630 N022_22 B22 N026_22 0 NMOS l=1u w=8u
M631 N026_22 A22 0 0 NMOS l=1u w=8u
M632 N024_22 C21 0 0 NMOS l=1u w=2u
M633 N024_22 B22 0 0 NMOS l=1u w=2u
M634 N024_22 A22 0 0 NMOS l=1u w=2u
M635 N021_22 N016_22 N024_22 0 NMOS l=1u w=2u
M636 N023_22 B22 0 0 NMOS l=1u w=2u
M637 N023_22 A22 0 0 NMOS l=1u w=2u
M638 N025_22 A22 0 0 NMOS l=1u w=2u
M639 N016_22 B22 N025_22 0 NMOS l=1u w=2u
M640 N016_22 C21 N023_22 0 NMOS l=1u w=2u
M641 C22 N016_22 0 0 NMOS l=1u w=1u
M642 N009_22 N016_22 N021_22 N014_22 PMOS l=1u w=4u
M643 N019_22 N021_22 SUM22 N019_22 PMOS l=1u w=2u
M644 SUM22 N021_22 0 0 NMOS l=1u w=1u
R309 VDD N002_22 0.001
R310 VDD N003_22 0.001
R311 VDD N004_22 0.001
R312 VDD N005_22 0.001
R313 VDD N006_22 0.001
R314 VDD N007_22 0.001
R315 VDD N013_22 0.001
R316 N012_22 VDD 0.001
R317 VDD N001_22 0.001
R318 VDD N019_22 0.001
R319 VDD N014_22 0.001
R320 VDD N015_22 0.001
R321 VDD N018_22 0.001
R322 VDD N020_22 0.001
C45 SUM22 0 1p
C46 C22 0 1p

* Bit 23
M645 N001_23 A23 N010_23 N001_23 PMOS l=1u w=4u
M646 N010_23 B23 N016_23 N012_23 PMOS l=1u w=4u
M647 N002_23 A23 N008_23 N002_23 PMOS l=1u w=4u
M648 N008_23 C22 N016_23 N013_23 PMOS l=1u w=4u
M649 N003_23 B23 N008_23 N003_23 PMOS l=1u w=4u
M650 VDD N016_23 C23 N020_23 PMOS l=1u w=2u
M651 N004_23 A23 N009_23 N004_23 PMOS l=1u w=4u
M652 N005_23 B23 N009_23 N005_23 PMOS l=1u w=4u
M653 N006_23 C22 N009_23 N006_23 PMOS l=1u w=4u
M654 N007_23 A23 N011_23 N007_23 PMOS l=1u w=8u
M655 N011_23 B23 N017_23 N015_23 PMOS l=1u w=8u
M656 N017_23 C22 N021_23 N018_23 PMOS l=1u w=8u
M657 N021_23 C22 N022_23 0 NMOS l=1u w=8u
M658 N022_23 B23 N026_23 0 NMOS l=1u w=8u
M659 N026_23 A23 0 0 NMOS l=1u w=8u
M660 N024_23 C22 0 0 NMOS l=1u w=2u
M661 N024_23 B23 0 0 NMOS l=1u w=2u
M662 N024_23 A23 0 0 NMOS l=1u w=2u
M663 N021_23 N016_23 N024_23 0 NMOS l=1u w=2u
M664 N023_23 B23 0 0 NMOS l=1u w=2u
M665 N023_23 A23 0 0 NMOS l=1u w=2u
M666 N025_23 A23 0 0 NMOS l=1u w=2u
M667 N016_23 B23 N025_23 0 NMOS l=1u w=2u
M668 N016_23 C22 N023_23 0 NMOS l=1u w=2u
M669 C23 N016_23 0 0 NMOS l=1u w=1u
M670 N009_23 N016_23 N021_23 N014_23 PMOS l=1u w=4u
M671 N019_23 N021_23 SUM23 N019_23 PMOS l=1u w=2u
M672 SUM23 N021_23 0 0 NMOS l=1u w=1u
R323 VDD N002_23 0.001
R324 VDD N003_23 0.001
R325 VDD N004_23 0.001
R326 VDD N005_23 0.001
R327 VDD N006_23 0.001
R328 VDD N007_23 0.001
R329 VDD N013_23 0.001
R330 N012_23 VDD 0.001
R331 VDD N001_23 0.001
R332 VDD N019_23 0.001
R333 VDD N014_23 0.001
R334 VDD N015_23 0.001
R335 VDD N018_23 0.001
R336 VDD N020_23 0.001
C47 SUM23 0 1p
C48 C23 0 1p

* Bit 24
M673 N001_24 A24 N010_24 N001_24 PMOS l=1u w=4u
M674 N010_24 B24 N016_24 N012_24 PMOS l=1u w=4u
M675 N002_24 A24 N008_24 N002_24 PMOS l=1u w=4u
M676 N008_24 C23 N016_24 N013_24 PMOS l=1u w=4u
M677 N003_24 B24 N008_24 N003_24 PMOS l=1u w=4u
M678 VDD N016_24 C24 N020_24 PMOS l=1u w=2u
M679 N004_24 A24 N009_24 N004_24 PMOS l=1u w=4u
M680 N005_24 B24 N009_24 N005_24 PMOS l=1u w=4u
M681 N006_24 C23 N009_24 N006_24 PMOS l=1u w=4u
M682 N007_24 A24 N011_24 N007_24 PMOS l=1u w=8u
M683 N011_24 B24 N017_24 N015_24 PMOS l=1u w=8u
M684 N017_24 C23 N021_24 N018_24 PMOS l=1u w=8u
M685 N021_24 C23 N022_24 0 NMOS l=1u w=8u
M686 N022_24 B24 N026_24 0 NMOS l=1u w=8u
M687 N026_24 A24 0 0 NMOS l=1u w=8u
M688 N024_24 C23 0 0 NMOS l=1u w=2u
M689 N024_24 B24 0 0 NMOS l=1u w=2u
M690 N024_24 A24 0 0 NMOS l=1u w=2u
M691 N021_24 N016_24 N024_24 0 NMOS l=1u w=2u
M692 N023_24 B24 0 0 NMOS l=1u w=2u
M693 N023_24 A24 0 0 NMOS l=1u w=2u
M694 N025_24 A24 0 0 NMOS l=1u w=2u
M695 N016_24 B24 N025_24 0 NMOS l=1u w=2u
M696 N016_24 C23 N023_24 0 NMOS l=1u w=2u
M697 C24 N016_24 0 0 NMOS l=1u w=1u
M698 N009_24 N016_24 N021_24 N014_24 PMOS l=1u w=4u
M699 N019_24 N021_24 SUM24 N019_24 PMOS l=1u w=2u
M700 SUM24 N021_24 0 0 NMOS l=1u w=1u
R337 VDD N002_24 0.001
R338 VDD N003_24 0.001
R339 VDD N004_24 0.001
R340 VDD N005_24 0.001
R341 VDD N006_24 0.001
R342 VDD N007_24 0.001
R343 VDD N013_24 0.001
R344 N012_24 VDD 0.001
R345 VDD N001_24 0.001
R346 VDD N019_24 0.001
R347 VDD N014_24 0.001
R348 VDD N015_24 0.001
R349 VDD N018_24 0.001
R350 VDD N020_24 0.001
C49 SUM24 0 1p
C50 C24 0 1p

* Bit 25
M701 N001_25 A25 N010_25 N001_25 PMOS l=1u w=4u
M702 N010_25 B25 N016_25 N012_25 PMOS l=1u w=4u
M703 N002_25 A25 N008_25 N002_25 PMOS l=1u w=4u
M704 N008_25 C24 N016_25 N013_25 PMOS l=1u w=4u
M705 N003_25 B25 N008_25 N003_25 PMOS l=1u w=4u
M706 VDD N016_25 C25 N020_25 PMOS l=1u w=2u
M707 N004_25 A25 N009_25 N004_25 PMOS l=1u w=4u
M708 N005_25 B25 N009_25 N005_25 PMOS l=1u w=4u
M709 N006_25 C24 N009_25 N006_25 PMOS l=1u w=4u
M710 N007_25 A25 N011_25 N007_25 PMOS l=1u w=8u
M711 N011_25 B25 N017_25 N015_25 PMOS l=1u w=8u
M712 N017_25 C24 N021_25 N018_25 PMOS l=1u w=8u
M713 N021_25 C24 N022_25 0 NMOS l=1u w=8u
M714 N022_25 B25 N026_25 0 NMOS l=1u w=8u
M715 N026_25 A25 0 0 NMOS l=1u w=8u
M716 N024_25 C24 0 0 NMOS l=1u w=2u
M717 N024_25 B25 0 0 NMOS l=1u w=2u
M718 N024_25 A25 0 0 NMOS l=1u w=2u
M719 N021_25 N016_25 N024_25 0 NMOS l=1u w=2u
M720 N023_25 B25 0 0 NMOS l=1u w=2u
M721 N023_25 A25 0 0 NMOS l=1u w=2u
M722 N025_25 A25 0 0 NMOS l=1u w=2u
M723 N016_25 B25 N025_25 0 NMOS l=1u w=2u
M724 N016_25 C24 N023_25 0 NMOS l=1u w=2u
M725 C25 N016_25 0 0 NMOS l=1u w=1u
M726 N009_25 N016_25 N021_25 N014_25 PMOS l=1u w=4u
M727 N019_25 N021_25 SUM25 N019_25 PMOS l=1u w=2u
M728 SUM25 N021_25 0 0 NMOS l=1u w=1u
R351 VDD N002_25 0.001
R352 VDD N003_25 0.001
R353 VDD N004_25 0.001
R354 VDD N005_25 0.001
R355 VDD N006_25 0.001
R356 VDD N007_25 0.001
R357 VDD N013_25 0.001
R358 N012_25 VDD 0.001
R359 VDD N001_25 0.001
R360 VDD N019_25 0.001
R361 VDD N014_25 0.001
R362 VDD N015_25 0.001
R363 VDD N018_25 0.001
R364 VDD N020_25 0.001
C51 SUM25 0 1p
C52 C25 0 1p

* Bit 26
M729 N001_26 A26 N010_26 N001_26 PMOS l=1u w=4u
M730 N010_26 B26 N016_26 N012_26 PMOS l=1u w=4u
M731 N002_26 A26 N008_26 N002_26 PMOS l=1u w=4u
M732 N008_26 C25 N016_26 N013_26 PMOS l=1u w=4u
M733 N003_26 B26 N008_26 N003_26 PMOS l=1u w=4u
M734 VDD N016_26 C26 N020_26 PMOS l=1u w=2u
M735 N004_26 A26 N009_26 N004_26 PMOS l=1u w=4u
M736 N005_26 B26 N009_26 N005_26 PMOS l=1u w=4u
M737 N006_26 C25 N009_26 N006_26 PMOS l=1u w=4u
M738 N007_26 A26 N011_26 N007_26 PMOS l=1u w=8u
M739 N011_26 B26 N017_26 N015_26 PMOS l=1u w=8u
M740 N017_26 C25 N021_26 N018_26 PMOS l=1u w=8u
M741 N021_26 C25 N022_26 0 NMOS l=1u w=8u
M742 N022_26 B26 N026_26 0 NMOS l=1u w=8u
M743 N026_26 A26 0 0 NMOS l=1u w=8u
M744 N024_26 C25 0 0 NMOS l=1u w=2u
M745 N024_26 B26 0 0 NMOS l=1u w=2u
M746 N024_26 A26 0 0 NMOS l=1u w=2u
M747 N021_26 N016_26 N024_26 0 NMOS l=1u w=2u
M748 N023_26 B26 0 0 NMOS l=1u w=2u
M749 N023_26 A26 0 0 NMOS l=1u w=2u
M750 N025_26 A26 0 0 NMOS l=1u w=2u
M751 N016_26 B26 N025_26 0 NMOS l=1u w=2u
M752 N016_26 C25 N023_26 0 NMOS l=1u w=2u
M753 C26 N016_26 0 0 NMOS l=1u w=1u
M754 N009_26 N016_26 N021_26 N014_26 PMOS l=1u w=4u
M755 N019_26 N021_26 SUM26 N019_26 PMOS l=1u w=2u
M756 SUM26 N021_26 0 0 NMOS l=1u w=1u
R365 VDD N002_26 0.001
R366 VDD N003_26 0.001
R367 VDD N004_26 0.001
R368 VDD N005_26 0.001
R369 VDD N006_26 0.001
R370 VDD N007_26 0.001
R371 VDD N013_26 0.001
R372 N012_26 VDD 0.001
R373 VDD N001_26 0.001
R374 VDD N019_26 0.001
R375 VDD N014_26 0.001
R376 VDD N015_26 0.001
R377 VDD N018_26 0.001
R378 VDD N020_26 0.001
C53 SUM26 0 1p
C54 C26 0 1p

* Bit 27
M757 N001_27 A27 N010_27 N001_27 PMOS l=1u w=4u
M758 N010_27 B27 N016_27 N012_27 PMOS l=1u w=4u
M759 N002_27 A27 N008_27 N002_27 PMOS l=1u w=4u
M760 N008_27 C26 N016_27 N013_27 PMOS l=1u w=4u
M761 N003_27 B27 N008_27 N003_27 PMOS l=1u w=4u
M762 VDD N016_27 C27 N020_27 PMOS l=1u w=2u
M763 N004_27 A27 N009_27 N004_27 PMOS l=1u w=4u
M764 N005_27 B27 N009_27 N005_27 PMOS l=1u w=4u
M765 N006_27 C26 N009_27 N006_27 PMOS l=1u w=4u
M766 N007_27 A27 N011_27 N007_27 PMOS l=1u w=8u
M767 N011_27 B27 N017_27 N015_27 PMOS l=1u w=8u
M768 N017_27 C26 N021_27 N018_27 PMOS l=1u w=8u
M769 N021_27 C26 N022_27 0 NMOS l=1u w=8u
M770 N022_27 B27 N026_27 0 NMOS l=1u w=8u
M771 N026_27 A27 0 0 NMOS l=1u w=8u
M772 N024_27 C26 0 0 NMOS l=1u w=2u
M773 N024_27 B27 0 0 NMOS l=1u w=2u
M774 N024_27 A27 0 0 NMOS l=1u w=2u
M775 N021_27 N016_27 N024_27 0 NMOS l=1u w=2u
M776 N023_27 B27 0 0 NMOS l=1u w=2u
M777 N023_27 A27 0 0 NMOS l=1u w=2u
M778 N025_27 A27 0 0 NMOS l=1u w=2u
M779 N016_27 B27 N025_27 0 NMOS l=1u w=2u
M780 N016_27 C26 N023_27 0 NMOS l=1u w=2u
M781 C27 N016_27 0 0 NMOS l=1u w=1u
M782 N009_27 N016_27 N021_27 N014_27 PMOS l=1u w=4u
M783 N019_27 N021_27 SUM27 N019_27 PMOS l=1u w=2u
M784 SUM27 N021_27 0 0 NMOS l=1u w=1u
R379 VDD N002_27 0.001
R380 VDD N003_27 0.001
R381 VDD N004_27 0.001
R382 VDD N005_27 0.001
R383 VDD N006_27 0.001
R384 VDD N007_27 0.001
R385 VDD N013_27 0.001
R386 N012_27 VDD 0.001
R387 VDD N001_27 0.001
R388 VDD N019_27 0.001
R389 VDD N014_27 0.001
R390 VDD N015_27 0.001
R391 VDD N018_27 0.001
R392 VDD N020_27 0.001
C55 SUM27 0 1p
C56 C27 0 1p

* Bit 28
M785 N001_28 A28 N010_28 N001_28 PMOS l=1u w=4u
M786 N010_28 B28 N016_28 N012_28 PMOS l=1u w=4u
M787 N002_28 A28 N008_28 N002_28 PMOS l=1u w=4u
M788 N008_28 C27 N016_28 N013_28 PMOS l=1u w=4u
M789 N003_28 B28 N008_28 N003_28 PMOS l=1u w=4u
M790 VDD N016_28 C28 N020_28 PMOS l=1u w=2u
M791 N004_28 A28 N009_28 N004_28 PMOS l=1u w=4u
M792 N005_28 B28 N009_28 N005_28 PMOS l=1u w=4u
M793 N006_28 C27 N009_28 N006_28 PMOS l=1u w=4u
M794 N007_28 A28 N011_28 N007_28 PMOS l=1u w=8u
M795 N011_28 B28 N017_28 N015_28 PMOS l=1u w=8u
M796 N017_28 C27 N021_28 N018_28 PMOS l=1u w=8u
M797 N021_28 C27 N022_28 0 NMOS l=1u w=8u
M798 N022_28 B28 N026_28 0 NMOS l=1u w=8u
M799 N026_28 A28 0 0 NMOS l=1u w=8u
M800 N024_28 C27 0 0 NMOS l=1u w=2u
M801 N024_28 B28 0 0 NMOS l=1u w=2u
M802 N024_28 A28 0 0 NMOS l=1u w=2u
M803 N021_28 N016_28 N024_28 0 NMOS l=1u w=2u
M804 N023_28 B28 0 0 NMOS l=1u w=2u
M805 N023_28 A28 0 0 NMOS l=1u w=2u
M806 N025_28 A28 0 0 NMOS l=1u w=2u
M807 N016_28 B28 N025_28 0 NMOS l=1u w=2u
M808 N016_28 C27 N023_28 0 NMOS l=1u w=2u
M809 C28 N016_28 0 0 NMOS l=1u w=1u
M810 N009_28 N016_28 N021_28 N014_28 PMOS l=1u w=4u
M811 N019_28 N021_28 SUM28 N019_28 PMOS l=1u w=2u
M812 SUM28 N021_28 0 0 NMOS l=1u w=1u
R393 VDD N002_28 0.001
R394 VDD N003_28 0.001
R395 VDD N004_28 0.001
R396 VDD N005_28 0.001
R397 VDD N006_28 0.001
R398 VDD N007_28 0.001
R399 VDD N013_28 0.001
R400 N012_28 VDD 0.001
R401 VDD N001_28 0.001
R402 VDD N019_28 0.001
R403 VDD N014_28 0.001
R404 VDD N015_28 0.001
R405 VDD N018_28 0.001
R406 VDD N020_28 0.001
C57 SUM28 0 1p
C58 C28 0 1p

* Bit 29
M813 N001_29 A29 N010_29 N001_29 PMOS l=1u w=4u
M814 N010_29 B29 N016_29 N012_29 PMOS l=1u w=4u
M815 N002_29 A29 N008_29 N002_29 PMOS l=1u w=4u
M816 N008_29 C28 N016_29 N013_29 PMOS l=1u w=4u
M817 N003_29 B29 N008_29 N003_29 PMOS l=1u w=4u
M818 VDD N016_29 C29 N020_29 PMOS l=1u w=2u
M819 N004_29 A29 N009_29 N004_29 PMOS l=1u w=4u
M820 N005_29 B29 N009_29 N005_29 PMOS l=1u w=4u
M821 N006_29 C28 N009_29 N006_29 PMOS l=1u w=4u
M822 N007_29 A29 N011_29 N007_29 PMOS l=1u w=8u
M823 N011_29 B29 N017_29 N015_29 PMOS l=1u w=8u
M824 N017_29 C28 N021_29 N018_29 PMOS l=1u w=8u
M825 N021_29 C28 N022_29 0 NMOS l=1u w=8u
M826 N022_29 B29 N026_29 0 NMOS l=1u w=8u
M827 N026_29 A29 0 0 NMOS l=1u w=8u
M828 N024_29 C28 0 0 NMOS l=1u w=2u
M829 N024_29 B29 0 0 NMOS l=1u w=2u
M830 N024_29 A29 0 0 NMOS l=1u w=2u
M831 N021_29 N016_29 N024_29 0 NMOS l=1u w=2u
M832 N023_29 B29 0 0 NMOS l=1u w=2u
M833 N023_29 A29 0 0 NMOS l=1u w=2u
M834 N025_29 A29 0 0 NMOS l=1u w=2u
M835 N016_29 B29 N025_29 0 NMOS l=1u w=2u
M836 N016_29 C28 N023_29 0 NMOS l=1u w=2u
M837 C29 N016_29 0 0 NMOS l=1u w=1u
M838 N009_29 N016_29 N021_29 N014_29 PMOS l=1u w=4u
M839 N019_29 N021_29 SUM29 N019_29 PMOS l=1u w=2u
M840 SUM29 N021_29 0 0 NMOS l=1u w=1u
R407 VDD N002_29 0.001
R408 VDD N003_29 0.001
R409 VDD N004_29 0.001
R410 VDD N005_29 0.001
R411 VDD N006_29 0.001
R412 VDD N007_29 0.001
R413 VDD N013_29 0.001
R414 N012_29 VDD 0.001
R415 VDD N001_29 0.001
R416 VDD N019_29 0.001
R417 VDD N014_29 0.001
R418 VDD N015_29 0.001
R419 VDD N018_29 0.001
R420 VDD N020_29 0.001
C59 SUM29 0 1p
C60 C29 0 1p

* Bit 30
M841 N001_30 A30 N010_30 N001_30 PMOS l=1u w=4u
M842 N010_30 B30 N016_30 N012_30 PMOS l=1u w=4u
M843 N002_30 A30 N008_30 N002_30 PMOS l=1u w=4u
M844 N008_30 C29 N016_30 N013_30 PMOS l=1u w=4u
M845 N003_30 B30 N008_30 N003_30 PMOS l=1u w=4u
M846 VDD N016_30 C30 N020_30 PMOS l=1u w=2u
M847 N004_30 A30 N009_30 N004_30 PMOS l=1u w=4u
M848 N005_30 B30 N009_30 N005_30 PMOS l=1u w=4u
M849 N006_30 C29 N009_30 N006_30 PMOS l=1u w=4u
M850 N007_30 A30 N011_30 N007_30 PMOS l=1u w=8u
M851 N011_30 B30 N017_30 N015_30 PMOS l=1u w=8u
M852 N017_30 C29 N021_30 N018_30 PMOS l=1u w=8u
M853 N021_30 C29 N022_30 0 NMOS l=1u w=8u
M854 N022_30 B30 N026_30 0 NMOS l=1u w=8u
M855 N026_30 A30 0 0 NMOS l=1u w=8u
M856 N024_30 C29 0 0 NMOS l=1u w=2u
M857 N024_30 B30 0 0 NMOS l=1u w=2u
M858 N024_30 A30 0 0 NMOS l=1u w=2u
M859 N021_30 N016_30 N024_30 0 NMOS l=1u w=2u
M860 N023_30 B30 0 0 NMOS l=1u w=2u
M861 N023_30 A30 0 0 NMOS l=1u w=2u
M862 N025_30 A30 0 0 NMOS l=1u w=2u
M863 N016_30 B30 N025_30 0 NMOS l=1u w=2u
M864 N016_30 C29 N023_30 0 NMOS l=1u w=2u
M865 C30 N016_30 0 0 NMOS l=1u w=1u
M866 N009_30 N016_30 N021_30 N014_30 PMOS l=1u w=4u
M867 N019_30 N021_30 SUM30 N019_30 PMOS l=1u w=2u
M868 SUM30 N021_30 0 0 NMOS l=1u w=1u
R421 VDD N002_30 0.001
R422 VDD N003_30 0.001
R423 VDD N004_30 0.001
R424 VDD N005_30 0.001
R425 VDD N006_30 0.001
R426 VDD N007_30 0.001
R427 VDD N013_30 0.001
R428 N012_30 VDD 0.001
R429 VDD N001_30 0.001
R430 VDD N019_30 0.001
R431 VDD N014_30 0.001
R432 VDD N015_30 0.001
R433 VDD N018_30 0.001
R434 VDD N020_30 0.001
C61 SUM30 0 1p
C62 C30 0 1p

* Bit 31
M869 N001_31 A31 N010_31 N001_31 PMOS l=1u w=4u
M870 N010_31 B31 N016_31 N012_31 PMOS l=1u w=4u
M871 N002_31 A31 N008_31 N002_31 PMOS l=1u w=4u
M872 N008_31 C30 N016_31 N013_31 PMOS l=1u w=4u
M873 N003_31 B31 N008_31 N003_31 PMOS l=1u w=4u
M874 VDD N016_31 C31 N020_31 PMOS l=1u w=2u
M875 N004_31 A31 N009_31 N004_31 PMOS l=1u w=4u
M876 N005_31 B31 N009_31 N005_31 PMOS l=1u w=4u
M877 N006_31 C30 N009_31 N006_31 PMOS l=1u w=4u
M878 N007_31 A31 N011_31 N007_31 PMOS l=1u w=8u
M879 N011_31 B31 N017_31 N015_31 PMOS l=1u w=8u
M880 N017_31 C30 N021_31 N018_31 PMOS l=1u w=8u
M881 N021_31 C30 N022_31 0 NMOS l=1u w=8u
M882 N022_31 B31 N026_31 0 NMOS l=1u w=8u
M883 N026_31 A31 0 0 NMOS l=1u w=8u
M884 N024_31 C30 0 0 NMOS l=1u w=2u
M885 N024_31 B31 0 0 NMOS l=1u w=2u
M886 N024_31 A31 0 0 NMOS l=1u w=2u
M887 N021_31 N016_31 N024_31 0 NMOS l=1u w=2u
M888 N023_31 B31 0 0 NMOS l=1u w=2u
M889 N023_31 A31 0 0 NMOS l=1u w=2u
M890 N025_31 A31 0 0 NMOS l=1u w=2u
M891 N016_31 B31 N025_31 0 NMOS l=1u w=2u
M892 N016_31 C30 N023_31 0 NMOS l=1u w=2u
M893 C31 N016_31 0 0 NMOS l=1u w=1u
M894 N009_31 N016_31 N021_31 N014_31 PMOS l=1u w=4u
M895 N019_31 N021_31 SUM31 N019_31 PMOS l=1u w=2u
M896 SUM31 N021_31 0 0 NMOS l=1u w=1u
R435 VDD N002_31 0.001
R436 VDD N003_31 0.001
R437 VDD N004_31 0.001
R438 VDD N005_31 0.001
R439 VDD N006_31 0.001
R440 VDD N007_31 0.001
R441 VDD N013_31 0.001
R442 N012_31 VDD 0.001
R443 VDD N001_31 0.001
R444 VDD N019_31 0.001
R445 VDD N014_31 0.001
R446 VDD N015_31 0.001
R447 VDD N018_31 0.001
R448 VDD N020_31 0.001
C63 SUM31 0 1p
C64 C31 0 1p

* Bit 32
M897 N001_32 A32 N010_32 N001_32 PMOS l=1u w=4u
M898 N010_32 B32 N016_32 N012_32 PMOS l=1u w=4u
M899 N002_32 A32 N008_32 N002_32 PMOS l=1u w=4u
M900 N008_32 C31 N016_32 N013_32 PMOS l=1u w=4u
M901 N003_32 B32 N008_32 N003_32 PMOS l=1u w=4u
M902 VDD N016_32 C32 N020_32 PMOS l=1u w=2u
M903 N004_32 A32 N009_32 N004_32 PMOS l=1u w=4u
M904 N005_32 B32 N009_32 N005_32 PMOS l=1u w=4u
M905 N006_32 C31 N009_32 N006_32 PMOS l=1u w=4u
M906 N007_32 A32 N011_32 N007_32 PMOS l=1u w=8u
M907 N011_32 B32 N017_32 N015_32 PMOS l=1u w=8u
M908 N017_32 C31 N021_32 N018_32 PMOS l=1u w=8u
M909 N021_32 C31 N022_32 0 NMOS l=1u w=8u
M910 N022_32 B32 N026_32 0 NMOS l=1u w=8u
M911 N026_32 A32 0 0 NMOS l=1u w=8u
M912 N024_32 C31 0 0 NMOS l=1u w=2u
M913 N024_32 B32 0 0 NMOS l=1u w=2u
M914 N024_32 A32 0 0 NMOS l=1u w=2u
M915 N021_32 N016_32 N024_32 0 NMOS l=1u w=2u
M916 N023_32 B32 0 0 NMOS l=1u w=2u
M917 N023_32 A32 0 0 NMOS l=1u w=2u
M918 N025_32 A32 0 0 NMOS l=1u w=2u
M919 N016_32 B32 N025_32 0 NMOS l=1u w=2u
M920 N016_32 C31 N023_32 0 NMOS l=1u w=2u
M921 C32 N016_32 0 0 NMOS l=1u w=1u
M922 N009_32 N016_32 N021_32 N014_32 PMOS l=1u w=4u
M923 N019_32 N021_32 SUM32 N019_32 PMOS l=1u w=2u
M924 SUM32 N021_32 0 0 NMOS l=1u w=1u
R449 VDD N002_32 0.001
R450 VDD N003_32 0.001
R451 VDD N004_32 0.001
R452 VDD N005_32 0.001
R453 VDD N006_32 0.001
R454 VDD N007_32 0.001
R455 VDD N013_32 0.001
R456 N012_32 VDD 0.001
R457 VDD N001_32 0.001
R458 VDD N019_32 0.001
R459 VDD N014_32 0.001
R460 VDD N015_32 0.001
R461 VDD N018_32 0.001
R462 VDD N020_32 0.001
C65 SUM32 0 1p
C66 C32 0 1p

* Bit 33
M925 N001_33 A33 N010_33 N001_33 PMOS l=1u w=4u
M926 N010_33 B33 N016_33 N012_33 PMOS l=1u w=4u
M927 N002_33 A33 N008_33 N002_33 PMOS l=1u w=4u
M928 N008_33 C32 N016_33 N013_33 PMOS l=1u w=4u
M929 N003_33 B33 N008_33 N003_33 PMOS l=1u w=4u
M930 VDD N016_33 C33 N020_33 PMOS l=1u w=2u
M931 N004_33 A33 N009_33 N004_33 PMOS l=1u w=4u
M932 N005_33 B33 N009_33 N005_33 PMOS l=1u w=4u
M933 N006_33 C32 N009_33 N006_33 PMOS l=1u w=4u
M934 N007_33 A33 N011_33 N007_33 PMOS l=1u w=8u
M935 N011_33 B33 N017_33 N015_33 PMOS l=1u w=8u
M936 N017_33 C32 N021_33 N018_33 PMOS l=1u w=8u
M937 N021_33 C32 N022_33 0 NMOS l=1u w=8u
M938 N022_33 B33 N026_33 0 NMOS l=1u w=8u
M939 N026_33 A33 0 0 NMOS l=1u w=8u
M940 N024_33 C32 0 0 NMOS l=1u w=2u
M941 N024_33 B33 0 0 NMOS l=1u w=2u
M942 N024_33 A33 0 0 NMOS l=1u w=2u
M943 N021_33 N016_33 N024_33 0 NMOS l=1u w=2u
M944 N023_33 B33 0 0 NMOS l=1u w=2u
M945 N023_33 A33 0 0 NMOS l=1u w=2u
M946 N025_33 A33 0 0 NMOS l=1u w=2u
M947 N016_33 B33 N025_33 0 NMOS l=1u w=2u
M948 N016_33 C32 N023_33 0 NMOS l=1u w=2u
M949 C33 N016_33 0 0 NMOS l=1u w=1u
M950 N009_33 N016_33 N021_33 N014_33 PMOS l=1u w=4u
M951 N019_33 N021_33 SUM33 N019_33 PMOS l=1u w=2u
M952 SUM33 N021_33 0 0 NMOS l=1u w=1u
R463 VDD N002_33 0.001
R464 VDD N003_33 0.001
R465 VDD N004_33 0.001
R466 VDD N005_33 0.001
R467 VDD N006_33 0.001
R468 VDD N007_33 0.001
R469 VDD N013_33 0.001
R470 N012_33 VDD 0.001
R471 VDD N001_33 0.001
R472 VDD N019_33 0.001
R473 VDD N014_33 0.001
R474 VDD N015_33 0.001
R475 VDD N018_33 0.001
R476 VDD N020_33 0.001
C67 SUM33 0 1p
C68 C33 0 1p

* Bit 34
M953 N001_34 A34 N010_34 N001_34 PMOS l=1u w=4u
M954 N010_34 B34 N016_34 N012_34 PMOS l=1u w=4u
M955 N002_34 A34 N008_34 N002_34 PMOS l=1u w=4u
M956 N008_34 C33 N016_34 N013_34 PMOS l=1u w=4u
M957 N003_34 B34 N008_34 N003_34 PMOS l=1u w=4u
M958 VDD N016_34 C34 N020_34 PMOS l=1u w=2u
M959 N004_34 A34 N009_34 N004_34 PMOS l=1u w=4u
M960 N005_34 B34 N009_34 N005_34 PMOS l=1u w=4u
M961 N006_34 C33 N009_34 N006_34 PMOS l=1u w=4u
M962 N007_34 A34 N011_34 N007_34 PMOS l=1u w=8u
M963 N011_34 B34 N017_34 N015_34 PMOS l=1u w=8u
M964 N017_34 C33 N021_34 N018_34 PMOS l=1u w=8u
M965 N021_34 C33 N022_34 0 NMOS l=1u w=8u
M966 N022_34 B34 N026_34 0 NMOS l=1u w=8u
M967 N026_34 A34 0 0 NMOS l=1u w=8u
M968 N024_34 C33 0 0 NMOS l=1u w=2u
M969 N024_34 B34 0 0 NMOS l=1u w=2u
M970 N024_34 A34 0 0 NMOS l=1u w=2u
M971 N021_34 N016_34 N024_34 0 NMOS l=1u w=2u
M972 N023_34 B34 0 0 NMOS l=1u w=2u
M973 N023_34 A34 0 0 NMOS l=1u w=2u
M974 N025_34 A34 0 0 NMOS l=1u w=2u
M975 N016_34 B34 N025_34 0 NMOS l=1u w=2u
M976 N016_34 C33 N023_34 0 NMOS l=1u w=2u
M977 C34 N016_34 0 0 NMOS l=1u w=1u
M978 N009_34 N016_34 N021_34 N014_34 PMOS l=1u w=4u
M979 N019_34 N021_34 SUM34 N019_34 PMOS l=1u w=2u
M980 SUM34 N021_34 0 0 NMOS l=1u w=1u
R477 VDD N002_34 0.001
R478 VDD N003_34 0.001
R479 VDD N004_34 0.001
R480 VDD N005_34 0.001
R481 VDD N006_34 0.001
R482 VDD N007_34 0.001
R483 VDD N013_34 0.001
R484 N012_34 VDD 0.001
R485 VDD N001_34 0.001
R486 VDD N019_34 0.001
R487 VDD N014_34 0.001
R488 VDD N015_34 0.001
R489 VDD N018_34 0.001
R490 VDD N020_34 0.001
C69 SUM34 0 1p
C70 C34 0 1p

* Bit 35
M981 N001_35 A35 N010_35 N001_35 PMOS l=1u w=4u
M982 N010_35 B35 N016_35 N012_35 PMOS l=1u w=4u
M983 N002_35 A35 N008_35 N002_35 PMOS l=1u w=4u
M984 N008_35 C34 N016_35 N013_35 PMOS l=1u w=4u
M985 N003_35 B35 N008_35 N003_35 PMOS l=1u w=4u
M986 VDD N016_35 C35 N020_35 PMOS l=1u w=2u
M987 N004_35 A35 N009_35 N004_35 PMOS l=1u w=4u
M988 N005_35 B35 N009_35 N005_35 PMOS l=1u w=4u
M989 N006_35 C34 N009_35 N006_35 PMOS l=1u w=4u
M990 N007_35 A35 N011_35 N007_35 PMOS l=1u w=8u
M991 N011_35 B35 N017_35 N015_35 PMOS l=1u w=8u
M992 N017_35 C34 N021_35 N018_35 PMOS l=1u w=8u
M993 N021_35 C34 N022_35 0 NMOS l=1u w=8u
M994 N022_35 B35 N026_35 0 NMOS l=1u w=8u
M995 N026_35 A35 0 0 NMOS l=1u w=8u
M996 N024_35 C34 0 0 NMOS l=1u w=2u
M997 N024_35 B35 0 0 NMOS l=1u w=2u
M998 N024_35 A35 0 0 NMOS l=1u w=2u
M999 N021_35 N016_35 N024_35 0 NMOS l=1u w=2u
M1000 N023_35 B35 0 0 NMOS l=1u w=2u
M1001 N023_35 A35 0 0 NMOS l=1u w=2u
M1002 N025_35 A35 0 0 NMOS l=1u w=2u
M1003 N016_35 B35 N025_35 0 NMOS l=1u w=2u
M1004 N016_35 C34 N023_35 0 NMOS l=1u w=2u
M1005 C35 N016_35 0 0 NMOS l=1u w=1u
M1006 N009_35 N016_35 N021_35 N014_35 PMOS l=1u w=4u
M1007 N019_35 N021_35 SUM35 N019_35 PMOS l=1u w=2u
M1008 SUM35 N021_35 0 0 NMOS l=1u w=1u
R491 VDD N002_35 0.001
R492 VDD N003_35 0.001
R493 VDD N004_35 0.001
R494 VDD N005_35 0.001
R495 VDD N006_35 0.001
R496 VDD N007_35 0.001
R497 VDD N013_35 0.001
R498 N012_35 VDD 0.001
R499 VDD N001_35 0.001
R500 VDD N019_35 0.001
R501 VDD N014_35 0.001
R502 VDD N015_35 0.001
R503 VDD N018_35 0.001
R504 VDD N020_35 0.001
C71 SUM35 0 1p
C72 C35 0 1p

* Bit 36
M1009 N001_36 A36 N010_36 N001_36 PMOS l=1u w=4u
M1010 N010_36 B36 N016_36 N012_36 PMOS l=1u w=4u
M1011 N002_36 A36 N008_36 N002_36 PMOS l=1u w=4u
M1012 N008_36 C35 N016_36 N013_36 PMOS l=1u w=4u
M1013 N003_36 B36 N008_36 N003_36 PMOS l=1u w=4u
M1014 VDD N016_36 C36 N020_36 PMOS l=1u w=2u
M1015 N004_36 A36 N009_36 N004_36 PMOS l=1u w=4u
M1016 N005_36 B36 N009_36 N005_36 PMOS l=1u w=4u
M1017 N006_36 C35 N009_36 N006_36 PMOS l=1u w=4u
M1018 N007_36 A36 N011_36 N007_36 PMOS l=1u w=8u
M1019 N011_36 B36 N017_36 N015_36 PMOS l=1u w=8u
M1020 N017_36 C35 N021_36 N018_36 PMOS l=1u w=8u
M1021 N021_36 C35 N022_36 0 NMOS l=1u w=8u
M1022 N022_36 B36 N026_36 0 NMOS l=1u w=8u
M1023 N026_36 A36 0 0 NMOS l=1u w=8u
M1024 N024_36 C35 0 0 NMOS l=1u w=2u
M1025 N024_36 B36 0 0 NMOS l=1u w=2u
M1026 N024_36 A36 0 0 NMOS l=1u w=2u
M1027 N021_36 N016_36 N024_36 0 NMOS l=1u w=2u
M1028 N023_36 B36 0 0 NMOS l=1u w=2u
M1029 N023_36 A36 0 0 NMOS l=1u w=2u
M1030 N025_36 A36 0 0 NMOS l=1u w=2u
M1031 N016_36 B36 N025_36 0 NMOS l=1u w=2u
M1032 N016_36 C35 N023_36 0 NMOS l=1u w=2u
M1033 C36 N016_36 0 0 NMOS l=1u w=1u
M1034 N009_36 N016_36 N021_36 N014_36 PMOS l=1u w=4u
M1035 N019_36 N021_36 SUM36 N019_36 PMOS l=1u w=2u
M1036 SUM36 N021_36 0 0 NMOS l=1u w=1u
R505 VDD N002_36 0.001
R506 VDD N003_36 0.001
R507 VDD N004_36 0.001
R508 VDD N005_36 0.001
R509 VDD N006_36 0.001
R510 VDD N007_36 0.001
R511 VDD N013_36 0.001
R512 N012_36 VDD 0.001
R513 VDD N001_36 0.001
R514 VDD N019_36 0.001
R515 VDD N014_36 0.001
R516 VDD N015_36 0.001
R517 VDD N018_36 0.001
R518 VDD N020_36 0.001
C73 SUM36 0 1p
C74 C36 0 1p

* Bit 37
M1037 N001_37 A37 N010_37 N001_37 PMOS l=1u w=4u
M1038 N010_37 B37 N016_37 N012_37 PMOS l=1u w=4u
M1039 N002_37 A37 N008_37 N002_37 PMOS l=1u w=4u
M1040 N008_37 C36 N016_37 N013_37 PMOS l=1u w=4u
M1041 N003_37 B37 N008_37 N003_37 PMOS l=1u w=4u
M1042 VDD N016_37 C37 N020_37 PMOS l=1u w=2u
M1043 N004_37 A37 N009_37 N004_37 PMOS l=1u w=4u
M1044 N005_37 B37 N009_37 N005_37 PMOS l=1u w=4u
M1045 N006_37 C36 N009_37 N006_37 PMOS l=1u w=4u
M1046 N007_37 A37 N011_37 N007_37 PMOS l=1u w=8u
M1047 N011_37 B37 N017_37 N015_37 PMOS l=1u w=8u
M1048 N017_37 C36 N021_37 N018_37 PMOS l=1u w=8u
M1049 N021_37 C36 N022_37 0 NMOS l=1u w=8u
M1050 N022_37 B37 N026_37 0 NMOS l=1u w=8u
M1051 N026_37 A37 0 0 NMOS l=1u w=8u
M1052 N024_37 C36 0 0 NMOS l=1u w=2u
M1053 N024_37 B37 0 0 NMOS l=1u w=2u
M1054 N024_37 A37 0 0 NMOS l=1u w=2u
M1055 N021_37 N016_37 N024_37 0 NMOS l=1u w=2u
M1056 N023_37 B37 0 0 NMOS l=1u w=2u
M1057 N023_37 A37 0 0 NMOS l=1u w=2u
M1058 N025_37 A37 0 0 NMOS l=1u w=2u
M1059 N016_37 B37 N025_37 0 NMOS l=1u w=2u
M1060 N016_37 C36 N023_37 0 NMOS l=1u w=2u
M1061 C37 N016_37 0 0 NMOS l=1u w=1u
M1062 N009_37 N016_37 N021_37 N014_37 PMOS l=1u w=4u
M1063 N019_37 N021_37 SUM37 N019_37 PMOS l=1u w=2u
M1064 SUM37 N021_37 0 0 NMOS l=1u w=1u
R519 VDD N002_37 0.001
R520 VDD N003_37 0.001
R521 VDD N004_37 0.001
R522 VDD N005_37 0.001
R523 VDD N006_37 0.001
R524 VDD N007_37 0.001
R525 VDD N013_37 0.001
R526 N012_37 VDD 0.001
R527 VDD N001_37 0.001
R528 VDD N019_37 0.001
R529 VDD N014_37 0.001
R530 VDD N015_37 0.001
R531 VDD N018_37 0.001
R532 VDD N020_37 0.001
C75 SUM37 0 1p
C76 C37 0 1p

* Bit 38
M1065 N001_38 A38 N010_38 N001_38 PMOS l=1u w=4u
M1066 N010_38 B38 N016_38 N012_38 PMOS l=1u w=4u
M1067 N002_38 A38 N008_38 N002_38 PMOS l=1u w=4u
M1068 N008_38 C37 N016_38 N013_38 PMOS l=1u w=4u
M1069 N003_38 B38 N008_38 N003_38 PMOS l=1u w=4u
M1070 VDD N016_38 C38 N020_38 PMOS l=1u w=2u
M1071 N004_38 A38 N009_38 N004_38 PMOS l=1u w=4u
M1072 N005_38 B38 N009_38 N005_38 PMOS l=1u w=4u
M1073 N006_38 C37 N009_38 N006_38 PMOS l=1u w=4u
M1074 N007_38 A38 N011_38 N007_38 PMOS l=1u w=8u
M1075 N011_38 B38 N017_38 N015_38 PMOS l=1u w=8u
M1076 N017_38 C37 N021_38 N018_38 PMOS l=1u w=8u
M1077 N021_38 C37 N022_38 0 NMOS l=1u w=8u
M1078 N022_38 B38 N026_38 0 NMOS l=1u w=8u
M1079 N026_38 A38 0 0 NMOS l=1u w=8u
M1080 N024_38 C37 0 0 NMOS l=1u w=2u
M1081 N024_38 B38 0 0 NMOS l=1u w=2u
M1082 N024_38 A38 0 0 NMOS l=1u w=2u
M1083 N021_38 N016_38 N024_38 0 NMOS l=1u w=2u
M1084 N023_38 B38 0 0 NMOS l=1u w=2u
M1085 N023_38 A38 0 0 NMOS l=1u w=2u
M1086 N025_38 A38 0 0 NMOS l=1u w=2u
M1087 N016_38 B38 N025_38 0 NMOS l=1u w=2u
M1088 N016_38 C37 N023_38 0 NMOS l=1u w=2u
M1089 C38 N016_38 0 0 NMOS l=1u w=1u
M1090 N009_38 N016_38 N021_38 N014_38 PMOS l=1u w=4u
M1091 N019_38 N021_38 SUM38 N019_38 PMOS l=1u w=2u
M1092 SUM38 N021_38 0 0 NMOS l=1u w=1u
R533 VDD N002_38 0.001
R534 VDD N003_38 0.001
R535 VDD N004_38 0.001
R536 VDD N005_38 0.001
R537 VDD N006_38 0.001
R538 VDD N007_38 0.001
R539 VDD N013_38 0.001
R540 N012_38 VDD 0.001
R541 VDD N001_38 0.001
R542 VDD N019_38 0.001
R543 VDD N014_38 0.001
R544 VDD N015_38 0.001
R545 VDD N018_38 0.001
R546 VDD N020_38 0.001
C77 SUM38 0 1p
C78 C38 0 1p

* Bit 39
M1093 N001_39 A39 N010_39 N001_39 PMOS l=1u w=4u
M1094 N010_39 B39 N016_39 N012_39 PMOS l=1u w=4u
M1095 N002_39 A39 N008_39 N002_39 PMOS l=1u w=4u
M1096 N008_39 C38 N016_39 N013_39 PMOS l=1u w=4u
M1097 N003_39 B39 N008_39 N003_39 PMOS l=1u w=4u
M1098 VDD N016_39 C39 N020_39 PMOS l=1u w=2u
M1099 N004_39 A39 N009_39 N004_39 PMOS l=1u w=4u
M1100 N005_39 B39 N009_39 N005_39 PMOS l=1u w=4u
M1101 N006_39 C38 N009_39 N006_39 PMOS l=1u w=4u
M1102 N007_39 A39 N011_39 N007_39 PMOS l=1u w=8u
M1103 N011_39 B39 N017_39 N015_39 PMOS l=1u w=8u
M1104 N017_39 C38 N021_39 N018_39 PMOS l=1u w=8u
M1105 N021_39 C38 N022_39 0 NMOS l=1u w=8u
M1106 N022_39 B39 N026_39 0 NMOS l=1u w=8u
M1107 N026_39 A39 0 0 NMOS l=1u w=8u
M1108 N024_39 C38 0 0 NMOS l=1u w=2u
M1109 N024_39 B39 0 0 NMOS l=1u w=2u
M1110 N024_39 A39 0 0 NMOS l=1u w=2u
M1111 N021_39 N016_39 N024_39 0 NMOS l=1u w=2u
M1112 N023_39 B39 0 0 NMOS l=1u w=2u
M1113 N023_39 A39 0 0 NMOS l=1u w=2u
M1114 N025_39 A39 0 0 NMOS l=1u w=2u
M1115 N016_39 B39 N025_39 0 NMOS l=1u w=2u
M1116 N016_39 C38 N023_39 0 NMOS l=1u w=2u
M1117 C39 N016_39 0 0 NMOS l=1u w=1u
M1118 N009_39 N016_39 N021_39 N014_39 PMOS l=1u w=4u
M1119 N019_39 N021_39 SUM39 N019_39 PMOS l=1u w=2u
M1120 SUM39 N021_39 0 0 NMOS l=1u w=1u
R547 VDD N002_39 0.001
R548 VDD N003_39 0.001
R549 VDD N004_39 0.001
R550 VDD N005_39 0.001
R551 VDD N006_39 0.001
R552 VDD N007_39 0.001
R553 VDD N013_39 0.001
R554 N012_39 VDD 0.001
R555 VDD N001_39 0.001
R556 VDD N019_39 0.001
R557 VDD N014_39 0.001
R558 VDD N015_39 0.001
R559 VDD N018_39 0.001
R560 VDD N020_39 0.001
C79 SUM39 0 1p
C80 C39 0 1p

* Bit 40
M1121 N001_40 A40 N010_40 N001_40 PMOS l=1u w=4u
M1122 N010_40 B40 N016_40 N012_40 PMOS l=1u w=4u
M1123 N002_40 A40 N008_40 N002_40 PMOS l=1u w=4u
M1124 N008_40 C39 N016_40 N013_40 PMOS l=1u w=4u
M1125 N003_40 B40 N008_40 N003_40 PMOS l=1u w=4u
M1126 VDD N016_40 C40 N020_40 PMOS l=1u w=2u
M1127 N004_40 A40 N009_40 N004_40 PMOS l=1u w=4u
M1128 N005_40 B40 N009_40 N005_40 PMOS l=1u w=4u
M1129 N006_40 C39 N009_40 N006_40 PMOS l=1u w=4u
M1130 N007_40 A40 N011_40 N007_40 PMOS l=1u w=8u
M1131 N011_40 B40 N017_40 N015_40 PMOS l=1u w=8u
M1132 N017_40 C39 N021_40 N018_40 PMOS l=1u w=8u
M1133 N021_40 C39 N022_40 0 NMOS l=1u w=8u
M1134 N022_40 B40 N026_40 0 NMOS l=1u w=8u
M1135 N026_40 A40 0 0 NMOS l=1u w=8u
M1136 N024_40 C39 0 0 NMOS l=1u w=2u
M1137 N024_40 B40 0 0 NMOS l=1u w=2u
M1138 N024_40 A40 0 0 NMOS l=1u w=2u
M1139 N021_40 N016_40 N024_40 0 NMOS l=1u w=2u
M1140 N023_40 B40 0 0 NMOS l=1u w=2u
M1141 N023_40 A40 0 0 NMOS l=1u w=2u
M1142 N025_40 A40 0 0 NMOS l=1u w=2u
M1143 N016_40 B40 N025_40 0 NMOS l=1u w=2u
M1144 N016_40 C39 N023_40 0 NMOS l=1u w=2u
M1145 C40 N016_40 0 0 NMOS l=1u w=1u
M1146 N009_40 N016_40 N021_40 N014_40 PMOS l=1u w=4u
M1147 N019_40 N021_40 SUM40 N019_40 PMOS l=1u w=2u
M1148 SUM40 N021_40 0 0 NMOS l=1u w=1u
R561 VDD N002_40 0.001
R562 VDD N003_40 0.001
R563 VDD N004_40 0.001
R564 VDD N005_40 0.001
R565 VDD N006_40 0.001
R566 VDD N007_40 0.001
R567 VDD N013_40 0.001
R568 N012_40 VDD 0.001
R569 VDD N001_40 0.001
R570 VDD N019_40 0.001
R571 VDD N014_40 0.001
R572 VDD N015_40 0.001
R573 VDD N018_40 0.001
R574 VDD N020_40 0.001
C81 SUM40 0 1p
C82 C40 0 1p

* Bit 41
M1149 N001_41 A41 N010_41 N001_41 PMOS l=1u w=4u
M1150 N010_41 B41 N016_41 N012_41 PMOS l=1u w=4u
M1151 N002_41 A41 N008_41 N002_41 PMOS l=1u w=4u
M1152 N008_41 C40 N016_41 N013_41 PMOS l=1u w=4u
M1153 N003_41 B41 N008_41 N003_41 PMOS l=1u w=4u
M1154 VDD N016_41 C41 N020_41 PMOS l=1u w=2u
M1155 N004_41 A41 N009_41 N004_41 PMOS l=1u w=4u
M1156 N005_41 B41 N009_41 N005_41 PMOS l=1u w=4u
M1157 N006_41 C40 N009_41 N006_41 PMOS l=1u w=4u
M1158 N007_41 A41 N011_41 N007_41 PMOS l=1u w=8u
M1159 N011_41 B41 N017_41 N015_41 PMOS l=1u w=8u
M1160 N017_41 C40 N021_41 N018_41 PMOS l=1u w=8u
M1161 N021_41 C40 N022_41 0 NMOS l=1u w=8u
M1162 N022_41 B41 N026_41 0 NMOS l=1u w=8u
M1163 N026_41 A41 0 0 NMOS l=1u w=8u
M1164 N024_41 C40 0 0 NMOS l=1u w=2u
M1165 N024_41 B41 0 0 NMOS l=1u w=2u
M1166 N024_41 A41 0 0 NMOS l=1u w=2u
M1167 N021_41 N016_41 N024_41 0 NMOS l=1u w=2u
M1168 N023_41 B41 0 0 NMOS l=1u w=2u
M1169 N023_41 A41 0 0 NMOS l=1u w=2u
M1170 N025_41 A41 0 0 NMOS l=1u w=2u
M1171 N016_41 B41 N025_41 0 NMOS l=1u w=2u
M1172 N016_41 C40 N023_41 0 NMOS l=1u w=2u
M1173 C41 N016_41 0 0 NMOS l=1u w=1u
M1174 N009_41 N016_41 N021_41 N014_41 PMOS l=1u w=4u
M1175 N019_41 N021_41 SUM41 N019_41 PMOS l=1u w=2u
M1176 SUM41 N021_41 0 0 NMOS l=1u w=1u
R575 VDD N002_41 0.001
R576 VDD N003_41 0.001
R577 VDD N004_41 0.001
R578 VDD N005_41 0.001
R579 VDD N006_41 0.001
R580 VDD N007_41 0.001
R581 VDD N013_41 0.001
R582 N012_41 VDD 0.001
R583 VDD N001_41 0.001
R584 VDD N019_41 0.001
R585 VDD N014_41 0.001
R586 VDD N015_41 0.001
R587 VDD N018_41 0.001
R588 VDD N020_41 0.001
C83 SUM41 0 1p
C84 C41 0 1p

* Bit 42
M1177 N001_42 A42 N010_42 N001_42 PMOS l=1u w=4u
M1178 N010_42 B42 N016_42 N012_42 PMOS l=1u w=4u
M1179 N002_42 A42 N008_42 N002_42 PMOS l=1u w=4u
M1180 N008_42 C41 N016_42 N013_42 PMOS l=1u w=4u
M1181 N003_42 B42 N008_42 N003_42 PMOS l=1u w=4u
M1182 VDD N016_42 C42 N020_42 PMOS l=1u w=2u
M1183 N004_42 A42 N009_42 N004_42 PMOS l=1u w=4u
M1184 N005_42 B42 N009_42 N005_42 PMOS l=1u w=4u
M1185 N006_42 C41 N009_42 N006_42 PMOS l=1u w=4u
M1186 N007_42 A42 N011_42 N007_42 PMOS l=1u w=8u
M1187 N011_42 B42 N017_42 N015_42 PMOS l=1u w=8u
M1188 N017_42 C41 N021_42 N018_42 PMOS l=1u w=8u
M1189 N021_42 C41 N022_42 0 NMOS l=1u w=8u
M1190 N022_42 B42 N026_42 0 NMOS l=1u w=8u
M1191 N026_42 A42 0 0 NMOS l=1u w=8u
M1192 N024_42 C41 0 0 NMOS l=1u w=2u
M1193 N024_42 B42 0 0 NMOS l=1u w=2u
M1194 N024_42 A42 0 0 NMOS l=1u w=2u
M1195 N021_42 N016_42 N024_42 0 NMOS l=1u w=2u
M1196 N023_42 B42 0 0 NMOS l=1u w=2u
M1197 N023_42 A42 0 0 NMOS l=1u w=2u
M1198 N025_42 A42 0 0 NMOS l=1u w=2u
M1199 N016_42 B42 N025_42 0 NMOS l=1u w=2u
M1200 N016_42 C41 N023_42 0 NMOS l=1u w=2u
M1201 C42 N016_42 0 0 NMOS l=1u w=1u
M1202 N009_42 N016_42 N021_42 N014_42 PMOS l=1u w=4u
M1203 N019_42 N021_42 SUM42 N019_42 PMOS l=1u w=2u
M1204 SUM42 N021_42 0 0 NMOS l=1u w=1u
R589 VDD N002_42 0.001
R590 VDD N003_42 0.001
R591 VDD N004_42 0.001
R592 VDD N005_42 0.001
R593 VDD N006_42 0.001
R594 VDD N007_42 0.001
R595 VDD N013_42 0.001
R596 N012_42 VDD 0.001
R597 VDD N001_42 0.001
R598 VDD N019_42 0.001
R599 VDD N014_42 0.001
R600 VDD N015_42 0.001
R601 VDD N018_42 0.001
R602 VDD N020_42 0.001
C85 SUM42 0 1p
C86 C42 0 1p

* Bit 43
M1205 N001_43 A43 N010_43 N001_43 PMOS l=1u w=4u
M1206 N010_43 B43 N016_43 N012_43 PMOS l=1u w=4u
M1207 N002_43 A43 N008_43 N002_43 PMOS l=1u w=4u
M1208 N008_43 C42 N016_43 N013_43 PMOS l=1u w=4u
M1209 N003_43 B43 N008_43 N003_43 PMOS l=1u w=4u
M1210 VDD N016_43 C43 N020_43 PMOS l=1u w=2u
M1211 N004_43 A43 N009_43 N004_43 PMOS l=1u w=4u
M1212 N005_43 B43 N009_43 N005_43 PMOS l=1u w=4u
M1213 N006_43 C42 N009_43 N006_43 PMOS l=1u w=4u
M1214 N007_43 A43 N011_43 N007_43 PMOS l=1u w=8u
M1215 N011_43 B43 N017_43 N015_43 PMOS l=1u w=8u
M1216 N017_43 C42 N021_43 N018_43 PMOS l=1u w=8u
M1217 N021_43 C42 N022_43 0 NMOS l=1u w=8u
M1218 N022_43 B43 N026_43 0 NMOS l=1u w=8u
M1219 N026_43 A43 0 0 NMOS l=1u w=8u
M1220 N024_43 C42 0 0 NMOS l=1u w=2u
M1221 N024_43 B43 0 0 NMOS l=1u w=2u
M1222 N024_43 A43 0 0 NMOS l=1u w=2u
M1223 N021_43 N016_43 N024_43 0 NMOS l=1u w=2u
M1224 N023_43 B43 0 0 NMOS l=1u w=2u
M1225 N023_43 A43 0 0 NMOS l=1u w=2u
M1226 N025_43 A43 0 0 NMOS l=1u w=2u
M1227 N016_43 B43 N025_43 0 NMOS l=1u w=2u
M1228 N016_43 C42 N023_43 0 NMOS l=1u w=2u
M1229 C43 N016_43 0 0 NMOS l=1u w=1u
M1230 N009_43 N016_43 N021_43 N014_43 PMOS l=1u w=4u
M1231 N019_43 N021_43 SUM43 N019_43 PMOS l=1u w=2u
M1232 SUM43 N021_43 0 0 NMOS l=1u w=1u
R603 VDD N002_43 0.001
R604 VDD N003_43 0.001
R605 VDD N004_43 0.001
R606 VDD N005_43 0.001
R607 VDD N006_43 0.001
R608 VDD N007_43 0.001
R609 VDD N013_43 0.001
R610 N012_43 VDD 0.001
R611 VDD N001_43 0.001
R612 VDD N019_43 0.001
R613 VDD N014_43 0.001
R614 VDD N015_43 0.001
R615 VDD N018_43 0.001
R616 VDD N020_43 0.001
C87 SUM43 0 1p
C88 C43 0 1p

* Bit 44
M1233 N001_44 A44 N010_44 N001_44 PMOS l=1u w=4u
M1234 N010_44 B44 N016_44 N012_44 PMOS l=1u w=4u
M1235 N002_44 A44 N008_44 N002_44 PMOS l=1u w=4u
M1236 N008_44 C43 N016_44 N013_44 PMOS l=1u w=4u
M1237 N003_44 B44 N008_44 N003_44 PMOS l=1u w=4u
M1238 VDD N016_44 C44 N020_44 PMOS l=1u w=2u
M1239 N004_44 A44 N009_44 N004_44 PMOS l=1u w=4u
M1240 N005_44 B44 N009_44 N005_44 PMOS l=1u w=4u
M1241 N006_44 C43 N009_44 N006_44 PMOS l=1u w=4u
M1242 N007_44 A44 N011_44 N007_44 PMOS l=1u w=8u
M1243 N011_44 B44 N017_44 N015_44 PMOS l=1u w=8u
M1244 N017_44 C43 N021_44 N018_44 PMOS l=1u w=8u
M1245 N021_44 C43 N022_44 0 NMOS l=1u w=8u
M1246 N022_44 B44 N026_44 0 NMOS l=1u w=8u
M1247 N026_44 A44 0 0 NMOS l=1u w=8u
M1248 N024_44 C43 0 0 NMOS l=1u w=2u
M1249 N024_44 B44 0 0 NMOS l=1u w=2u
M1250 N024_44 A44 0 0 NMOS l=1u w=2u
M1251 N021_44 N016_44 N024_44 0 NMOS l=1u w=2u
M1252 N023_44 B44 0 0 NMOS l=1u w=2u
M1253 N023_44 A44 0 0 NMOS l=1u w=2u
M1254 N025_44 A44 0 0 NMOS l=1u w=2u
M1255 N016_44 B44 N025_44 0 NMOS l=1u w=2u
M1256 N016_44 C43 N023_44 0 NMOS l=1u w=2u
M1257 C44 N016_44 0 0 NMOS l=1u w=1u
M1258 N009_44 N016_44 N021_44 N014_44 PMOS l=1u w=4u
M1259 N019_44 N021_44 SUM44 N019_44 PMOS l=1u w=2u
M1260 SUM44 N021_44 0 0 NMOS l=1u w=1u
R617 VDD N002_44 0.001
R618 VDD N003_44 0.001
R619 VDD N004_44 0.001
R620 VDD N005_44 0.001
R621 VDD N006_44 0.001
R622 VDD N007_44 0.001
R623 VDD N013_44 0.001
R624 N012_44 VDD 0.001
R625 VDD N001_44 0.001
R626 VDD N019_44 0.001
R627 VDD N014_44 0.001
R628 VDD N015_44 0.001
R629 VDD N018_44 0.001
R630 VDD N020_44 0.001
C89 SUM44 0 1p
C90 C44 0 1p

* Bit 45
M1261 N001_45 A45 N010_45 N001_45 PMOS l=1u w=4u
M1262 N010_45 B45 N016_45 N012_45 PMOS l=1u w=4u
M1263 N002_45 A45 N008_45 N002_45 PMOS l=1u w=4u
M1264 N008_45 C44 N016_45 N013_45 PMOS l=1u w=4u
M1265 N003_45 B45 N008_45 N003_45 PMOS l=1u w=4u
M1266 VDD N016_45 C45 N020_45 PMOS l=1u w=2u
M1267 N004_45 A45 N009_45 N004_45 PMOS l=1u w=4u
M1268 N005_45 B45 N009_45 N005_45 PMOS l=1u w=4u
M1269 N006_45 C44 N009_45 N006_45 PMOS l=1u w=4u
M1270 N007_45 A45 N011_45 N007_45 PMOS l=1u w=8u
M1271 N011_45 B45 N017_45 N015_45 PMOS l=1u w=8u
M1272 N017_45 C44 N021_45 N018_45 PMOS l=1u w=8u
M1273 N021_45 C44 N022_45 0 NMOS l=1u w=8u
M1274 N022_45 B45 N026_45 0 NMOS l=1u w=8u
M1275 N026_45 A45 0 0 NMOS l=1u w=8u
M1276 N024_45 C44 0 0 NMOS l=1u w=2u
M1277 N024_45 B45 0 0 NMOS l=1u w=2u
M1278 N024_45 A45 0 0 NMOS l=1u w=2u
M1279 N021_45 N016_45 N024_45 0 NMOS l=1u w=2u
M1280 N023_45 B45 0 0 NMOS l=1u w=2u
M1281 N023_45 A45 0 0 NMOS l=1u w=2u
M1282 N025_45 A45 0 0 NMOS l=1u w=2u
M1283 N016_45 B45 N025_45 0 NMOS l=1u w=2u
M1284 N016_45 C44 N023_45 0 NMOS l=1u w=2u
M1285 C45 N016_45 0 0 NMOS l=1u w=1u
M1286 N009_45 N016_45 N021_45 N014_45 PMOS l=1u w=4u
M1287 N019_45 N021_45 SUM45 N019_45 PMOS l=1u w=2u
M1288 SUM45 N021_45 0 0 NMOS l=1u w=1u
R631 VDD N002_45 0.001
R632 VDD N003_45 0.001
R633 VDD N004_45 0.001
R634 VDD N005_45 0.001
R635 VDD N006_45 0.001
R636 VDD N007_45 0.001
R637 VDD N013_45 0.001
R638 N012_45 VDD 0.001
R639 VDD N001_45 0.001
R640 VDD N019_45 0.001
R641 VDD N014_45 0.001
R642 VDD N015_45 0.001
R643 VDD N018_45 0.001
R644 VDD N020_45 0.001
C91 SUM45 0 1p
C92 C45 0 1p

* Bit 46
M1289 N001_46 A46 N010_46 N001_46 PMOS l=1u w=4u
M1290 N010_46 B46 N016_46 N012_46 PMOS l=1u w=4u
M1291 N002_46 A46 N008_46 N002_46 PMOS l=1u w=4u
M1292 N008_46 C45 N016_46 N013_46 PMOS l=1u w=4u
M1293 N003_46 B46 N008_46 N003_46 PMOS l=1u w=4u
M1294 VDD N016_46 C46 N020_46 PMOS l=1u w=2u
M1295 N004_46 A46 N009_46 N004_46 PMOS l=1u w=4u
M1296 N005_46 B46 N009_46 N005_46 PMOS l=1u w=4u
M1297 N006_46 C45 N009_46 N006_46 PMOS l=1u w=4u
M1298 N007_46 A46 N011_46 N007_46 PMOS l=1u w=8u
M1299 N011_46 B46 N017_46 N015_46 PMOS l=1u w=8u
M1300 N017_46 C45 N021_46 N018_46 PMOS l=1u w=8u
M1301 N021_46 C45 N022_46 0 NMOS l=1u w=8u
M1302 N022_46 B46 N026_46 0 NMOS l=1u w=8u
M1303 N026_46 A46 0 0 NMOS l=1u w=8u
M1304 N024_46 C45 0 0 NMOS l=1u w=2u
M1305 N024_46 B46 0 0 NMOS l=1u w=2u
M1306 N024_46 A46 0 0 NMOS l=1u w=2u
M1307 N021_46 N016_46 N024_46 0 NMOS l=1u w=2u
M1308 N023_46 B46 0 0 NMOS l=1u w=2u
M1309 N023_46 A46 0 0 NMOS l=1u w=2u
M1310 N025_46 A46 0 0 NMOS l=1u w=2u
M1311 N016_46 B46 N025_46 0 NMOS l=1u w=2u
M1312 N016_46 C45 N023_46 0 NMOS l=1u w=2u
M1313 C46 N016_46 0 0 NMOS l=1u w=1u
M1314 N009_46 N016_46 N021_46 N014_46 PMOS l=1u w=4u
M1315 N019_46 N021_46 SUM46 N019_46 PMOS l=1u w=2u
M1316 SUM46 N021_46 0 0 NMOS l=1u w=1u
R645 VDD N002_46 0.001
R646 VDD N003_46 0.001
R647 VDD N004_46 0.001
R648 VDD N005_46 0.001
R649 VDD N006_46 0.001
R650 VDD N007_46 0.001
R651 VDD N013_46 0.001
R652 N012_46 VDD 0.001
R653 VDD N001_46 0.001
R654 VDD N019_46 0.001
R655 VDD N014_46 0.001
R656 VDD N015_46 0.001
R657 VDD N018_46 0.001
R658 VDD N020_46 0.001
C93 SUM46 0 1p
C94 C46 0 1p

* Bit 47
M1317 N001_47 A47 N010_47 N001_47 PMOS l=1u w=4u
M1318 N010_47 B47 N016_47 N012_47 PMOS l=1u w=4u
M1319 N002_47 A47 N008_47 N002_47 PMOS l=1u w=4u
M1320 N008_47 C46 N016_47 N013_47 PMOS l=1u w=4u
M1321 N003_47 B47 N008_47 N003_47 PMOS l=1u w=4u
M1322 VDD N016_47 C47 N020_47 PMOS l=1u w=2u
M1323 N004_47 A47 N009_47 N004_47 PMOS l=1u w=4u
M1324 N005_47 B47 N009_47 N005_47 PMOS l=1u w=4u
M1325 N006_47 C46 N009_47 N006_47 PMOS l=1u w=4u
M1326 N007_47 A47 N011_47 N007_47 PMOS l=1u w=8u
M1327 N011_47 B47 N017_47 N015_47 PMOS l=1u w=8u
M1328 N017_47 C46 N021_47 N018_47 PMOS l=1u w=8u
M1329 N021_47 C46 N022_47 0 NMOS l=1u w=8u
M1330 N022_47 B47 N026_47 0 NMOS l=1u w=8u
M1331 N026_47 A47 0 0 NMOS l=1u w=8u
M1332 N024_47 C46 0 0 NMOS l=1u w=2u
M1333 N024_47 B47 0 0 NMOS l=1u w=2u
M1334 N024_47 A47 0 0 NMOS l=1u w=2u
M1335 N021_47 N016_47 N024_47 0 NMOS l=1u w=2u
M1336 N023_47 B47 0 0 NMOS l=1u w=2u
M1337 N023_47 A47 0 0 NMOS l=1u w=2u
M1338 N025_47 A47 0 0 NMOS l=1u w=2u
M1339 N016_47 B47 N025_47 0 NMOS l=1u w=2u
M1340 N016_47 C46 N023_47 0 NMOS l=1u w=2u
M1341 C47 N016_47 0 0 NMOS l=1u w=1u
M1342 N009_47 N016_47 N021_47 N014_47 PMOS l=1u w=4u
M1343 N019_47 N021_47 SUM47 N019_47 PMOS l=1u w=2u
M1344 SUM47 N021_47 0 0 NMOS l=1u w=1u
R659 VDD N002_47 0.001
R660 VDD N003_47 0.001
R661 VDD N004_47 0.001
R662 VDD N005_47 0.001
R663 VDD N006_47 0.001
R664 VDD N007_47 0.001
R665 VDD N013_47 0.001
R666 N012_47 VDD 0.001
R667 VDD N001_47 0.001
R668 VDD N019_47 0.001
R669 VDD N014_47 0.001
R670 VDD N015_47 0.001
R671 VDD N018_47 0.001
R672 VDD N020_47 0.001
C95 SUM47 0 1p
C96 C47 0 1p

* Bit 48
M1345 N001_48 A48 N010_48 N001_48 PMOS l=1u w=4u
M1346 N010_48 B48 N016_48 N012_48 PMOS l=1u w=4u
M1347 N002_48 A48 N008_48 N002_48 PMOS l=1u w=4u
M1348 N008_48 C47 N016_48 N013_48 PMOS l=1u w=4u
M1349 N003_48 B48 N008_48 N003_48 PMOS l=1u w=4u
M1350 VDD N016_48 C48 N020_48 PMOS l=1u w=2u
M1351 N004_48 A48 N009_48 N004_48 PMOS l=1u w=4u
M1352 N005_48 B48 N009_48 N005_48 PMOS l=1u w=4u
M1353 N006_48 C47 N009_48 N006_48 PMOS l=1u w=4u
M1354 N007_48 A48 N011_48 N007_48 PMOS l=1u w=8u
M1355 N011_48 B48 N017_48 N015_48 PMOS l=1u w=8u
M1356 N017_48 C47 N021_48 N018_48 PMOS l=1u w=8u
M1357 N021_48 C47 N022_48 0 NMOS l=1u w=8u
M1358 N022_48 B48 N026_48 0 NMOS l=1u w=8u
M1359 N026_48 A48 0 0 NMOS l=1u w=8u
M1360 N024_48 C47 0 0 NMOS l=1u w=2u
M1361 N024_48 B48 0 0 NMOS l=1u w=2u
M1362 N024_48 A48 0 0 NMOS l=1u w=2u
M1363 N021_48 N016_48 N024_48 0 NMOS l=1u w=2u
M1364 N023_48 B48 0 0 NMOS l=1u w=2u
M1365 N023_48 A48 0 0 NMOS l=1u w=2u
M1366 N025_48 A48 0 0 NMOS l=1u w=2u
M1367 N016_48 B48 N025_48 0 NMOS l=1u w=2u
M1368 N016_48 C47 N023_48 0 NMOS l=1u w=2u
M1369 C48 N016_48 0 0 NMOS l=1u w=1u
M1370 N009_48 N016_48 N021_48 N014_48 PMOS l=1u w=4u
M1371 N019_48 N021_48 SUM48 N019_48 PMOS l=1u w=2u
M1372 SUM48 N021_48 0 0 NMOS l=1u w=1u
R673 VDD N002_48 0.001
R674 VDD N003_48 0.001
R675 VDD N004_48 0.001
R676 VDD N005_48 0.001
R677 VDD N006_48 0.001
R678 VDD N007_48 0.001
R679 VDD N013_48 0.001
R680 N012_48 VDD 0.001
R681 VDD N001_48 0.001
R682 VDD N019_48 0.001
R683 VDD N014_48 0.001
R684 VDD N015_48 0.001
R685 VDD N018_48 0.001
R686 VDD N020_48 0.001
C97 SUM48 0 1p
C98 C48 0 1p

* Bit 49
M1373 N001_49 A49 N010_49 N001_49 PMOS l=1u w=4u
M1374 N010_49 B49 N016_49 N012_49 PMOS l=1u w=4u
M1375 N002_49 A49 N008_49 N002_49 PMOS l=1u w=4u
M1376 N008_49 C48 N016_49 N013_49 PMOS l=1u w=4u
M1377 N003_49 B49 N008_49 N003_49 PMOS l=1u w=4u
M1378 VDD N016_49 C49 N020_49 PMOS l=1u w=2u
M1379 N004_49 A49 N009_49 N004_49 PMOS l=1u w=4u
M1380 N005_49 B49 N009_49 N005_49 PMOS l=1u w=4u
M1381 N006_49 C48 N009_49 N006_49 PMOS l=1u w=4u
M1382 N007_49 A49 N011_49 N007_49 PMOS l=1u w=8u
M1383 N011_49 B49 N017_49 N015_49 PMOS l=1u w=8u
M1384 N017_49 C48 N021_49 N018_49 PMOS l=1u w=8u
M1385 N021_49 C48 N022_49 0 NMOS l=1u w=8u
M1386 N022_49 B49 N026_49 0 NMOS l=1u w=8u
M1387 N026_49 A49 0 0 NMOS l=1u w=8u
M1388 N024_49 C48 0 0 NMOS l=1u w=2u
M1389 N024_49 B49 0 0 NMOS l=1u w=2u
M1390 N024_49 A49 0 0 NMOS l=1u w=2u
M1391 N021_49 N016_49 N024_49 0 NMOS l=1u w=2u
M1392 N023_49 B49 0 0 NMOS l=1u w=2u
M1393 N023_49 A49 0 0 NMOS l=1u w=2u
M1394 N025_49 A49 0 0 NMOS l=1u w=2u
M1395 N016_49 B49 N025_49 0 NMOS l=1u w=2u
M1396 N016_49 C48 N023_49 0 NMOS l=1u w=2u
M1397 C49 N016_49 0 0 NMOS l=1u w=1u
M1398 N009_49 N016_49 N021_49 N014_49 PMOS l=1u w=4u
M1399 N019_49 N021_49 SUM49 N019_49 PMOS l=1u w=2u
M1400 SUM49 N021_49 0 0 NMOS l=1u w=1u
R687 VDD N002_49 0.001
R688 VDD N003_49 0.001
R689 VDD N004_49 0.001
R690 VDD N005_49 0.001
R691 VDD N006_49 0.001
R692 VDD N007_49 0.001
R693 VDD N013_49 0.001
R694 N012_49 VDD 0.001
R695 VDD N001_49 0.001
R696 VDD N019_49 0.001
R697 VDD N014_49 0.001
R698 VDD N015_49 0.001
R699 VDD N018_49 0.001
R700 VDD N020_49 0.001
C99 SUM49 0 1p
C100 C49 0 1p

* Bit 50
M1401 N001_50 A50 N010_50 N001_50 PMOS l=1u w=4u
M1402 N010_50 B50 N016_50 N012_50 PMOS l=1u w=4u
M1403 N002_50 A50 N008_50 N002_50 PMOS l=1u w=4u
M1404 N008_50 C49 N016_50 N013_50 PMOS l=1u w=4u
M1405 N003_50 B50 N008_50 N003_50 PMOS l=1u w=4u
M1406 VDD N016_50 C50 N020_50 PMOS l=1u w=2u
M1407 N004_50 A50 N009_50 N004_50 PMOS l=1u w=4u
M1408 N005_50 B50 N009_50 N005_50 PMOS l=1u w=4u
M1409 N006_50 C49 N009_50 N006_50 PMOS l=1u w=4u
M1410 N007_50 A50 N011_50 N007_50 PMOS l=1u w=8u
M1411 N011_50 B50 N017_50 N015_50 PMOS l=1u w=8u
M1412 N017_50 C49 N021_50 N018_50 PMOS l=1u w=8u
M1413 N021_50 C49 N022_50 0 NMOS l=1u w=8u
M1414 N022_50 B50 N026_50 0 NMOS l=1u w=8u
M1415 N026_50 A50 0 0 NMOS l=1u w=8u
M1416 N024_50 C49 0 0 NMOS l=1u w=2u
M1417 N024_50 B50 0 0 NMOS l=1u w=2u
M1418 N024_50 A50 0 0 NMOS l=1u w=2u
M1419 N021_50 N016_50 N024_50 0 NMOS l=1u w=2u
M1420 N023_50 B50 0 0 NMOS l=1u w=2u
M1421 N023_50 A50 0 0 NMOS l=1u w=2u
M1422 N025_50 A50 0 0 NMOS l=1u w=2u
M1423 N016_50 B50 N025_50 0 NMOS l=1u w=2u
M1424 N016_50 C49 N023_50 0 NMOS l=1u w=2u
M1425 C50 N016_50 0 0 NMOS l=1u w=1u
M1426 N009_50 N016_50 N021_50 N014_50 PMOS l=1u w=4u
M1427 N019_50 N021_50 SUM50 N019_50 PMOS l=1u w=2u
M1428 SUM50 N021_50 0 0 NMOS l=1u w=1u
R701 VDD N002_50 0.001
R702 VDD N003_50 0.001
R703 VDD N004_50 0.001
R704 VDD N005_50 0.001
R705 VDD N006_50 0.001
R706 VDD N007_50 0.001
R707 VDD N013_50 0.001
R708 N012_50 VDD 0.001
R709 VDD N001_50 0.001
R710 VDD N019_50 0.001
R711 VDD N014_50 0.001
R712 VDD N015_50 0.001
R713 VDD N018_50 0.001
R714 VDD N020_50 0.001
C101 SUM50 0 1p
C102 C50 0 1p

* Bit 51
M1429 N001_51 A51 N010_51 N001_51 PMOS l=1u w=4u
M1430 N010_51 B51 N016_51 N012_51 PMOS l=1u w=4u
M1431 N002_51 A51 N008_51 N002_51 PMOS l=1u w=4u
M1432 N008_51 C50 N016_51 N013_51 PMOS l=1u w=4u
M1433 N003_51 B51 N008_51 N003_51 PMOS l=1u w=4u
M1434 VDD N016_51 C51 N020_51 PMOS l=1u w=2u
M1435 N004_51 A51 N009_51 N004_51 PMOS l=1u w=4u
M1436 N005_51 B51 N009_51 N005_51 PMOS l=1u w=4u
M1437 N006_51 C50 N009_51 N006_51 PMOS l=1u w=4u
M1438 N007_51 A51 N011_51 N007_51 PMOS l=1u w=8u
M1439 N011_51 B51 N017_51 N015_51 PMOS l=1u w=8u
M1440 N017_51 C50 N021_51 N018_51 PMOS l=1u w=8u
M1441 N021_51 C50 N022_51 0 NMOS l=1u w=8u
M1442 N022_51 B51 N026_51 0 NMOS l=1u w=8u
M1443 N026_51 A51 0 0 NMOS l=1u w=8u
M1444 N024_51 C50 0 0 NMOS l=1u w=2u
M1445 N024_51 B51 0 0 NMOS l=1u w=2u
M1446 N024_51 A51 0 0 NMOS l=1u w=2u
M1447 N021_51 N016_51 N024_51 0 NMOS l=1u w=2u
M1448 N023_51 B51 0 0 NMOS l=1u w=2u
M1449 N023_51 A51 0 0 NMOS l=1u w=2u
M1450 N025_51 A51 0 0 NMOS l=1u w=2u
M1451 N016_51 B51 N025_51 0 NMOS l=1u w=2u
M1452 N016_51 C50 N023_51 0 NMOS l=1u w=2u
M1453 C51 N016_51 0 0 NMOS l=1u w=1u
M1454 N009_51 N016_51 N021_51 N014_51 PMOS l=1u w=4u
M1455 N019_51 N021_51 SUM51 N019_51 PMOS l=1u w=2u
M1456 SUM51 N021_51 0 0 NMOS l=1u w=1u
R715 VDD N002_51 0.001
R716 VDD N003_51 0.001
R717 VDD N004_51 0.001
R718 VDD N005_51 0.001
R719 VDD N006_51 0.001
R720 VDD N007_51 0.001
R721 VDD N013_51 0.001
R722 N012_51 VDD 0.001
R723 VDD N001_51 0.001
R724 VDD N019_51 0.001
R725 VDD N014_51 0.001
R726 VDD N015_51 0.001
R727 VDD N018_51 0.001
R728 VDD N020_51 0.001
C103 SUM51 0 1p
C104 C51 0 1p

* Bit 52
M1457 N001_52 A52 N010_52 N001_52 PMOS l=1u w=4u
M1458 N010_52 B52 N016_52 N012_52 PMOS l=1u w=4u
M1459 N002_52 A52 N008_52 N002_52 PMOS l=1u w=4u
M1460 N008_52 C51 N016_52 N013_52 PMOS l=1u w=4u
M1461 N003_52 B52 N008_52 N003_52 PMOS l=1u w=4u
M1462 VDD N016_52 C52 N020_52 PMOS l=1u w=2u
M1463 N004_52 A52 N009_52 N004_52 PMOS l=1u w=4u
M1464 N005_52 B52 N009_52 N005_52 PMOS l=1u w=4u
M1465 N006_52 C51 N009_52 N006_52 PMOS l=1u w=4u
M1466 N007_52 A52 N011_52 N007_52 PMOS l=1u w=8u
M1467 N011_52 B52 N017_52 N015_52 PMOS l=1u w=8u
M1468 N017_52 C51 N021_52 N018_52 PMOS l=1u w=8u
M1469 N021_52 C51 N022_52 0 NMOS l=1u w=8u
M1470 N022_52 B52 N026_52 0 NMOS l=1u w=8u
M1471 N026_52 A52 0 0 NMOS l=1u w=8u
M1472 N024_52 C51 0 0 NMOS l=1u w=2u
M1473 N024_52 B52 0 0 NMOS l=1u w=2u
M1474 N024_52 A52 0 0 NMOS l=1u w=2u
M1475 N021_52 N016_52 N024_52 0 NMOS l=1u w=2u
M1476 N023_52 B52 0 0 NMOS l=1u w=2u
M1477 N023_52 A52 0 0 NMOS l=1u w=2u
M1478 N025_52 A52 0 0 NMOS l=1u w=2u
M1479 N016_52 B52 N025_52 0 NMOS l=1u w=2u
M1480 N016_52 C51 N023_52 0 NMOS l=1u w=2u
M1481 C52 N016_52 0 0 NMOS l=1u w=1u
M1482 N009_52 N016_52 N021_52 N014_52 PMOS l=1u w=4u
M1483 N019_52 N021_52 SUM52 N019_52 PMOS l=1u w=2u
M1484 SUM52 N021_52 0 0 NMOS l=1u w=1u
R729 VDD N002_52 0.001
R730 VDD N003_52 0.001
R731 VDD N004_52 0.001
R732 VDD N005_52 0.001
R733 VDD N006_52 0.001
R734 VDD N007_52 0.001
R735 VDD N013_52 0.001
R736 N012_52 VDD 0.001
R737 VDD N001_52 0.001
R738 VDD N019_52 0.001
R739 VDD N014_52 0.001
R740 VDD N015_52 0.001
R741 VDD N018_52 0.001
R742 VDD N020_52 0.001
C105 SUM52 0 1p
C106 C52 0 1p

* Bit 53
M1485 N001_53 A53 N010_53 N001_53 PMOS l=1u w=4u
M1486 N010_53 B53 N016_53 N012_53 PMOS l=1u w=4u
M1487 N002_53 A53 N008_53 N002_53 PMOS l=1u w=4u
M1488 N008_53 C52 N016_53 N013_53 PMOS l=1u w=4u
M1489 N003_53 B53 N008_53 N003_53 PMOS l=1u w=4u
M1490 VDD N016_53 C53 N020_53 PMOS l=1u w=2u
M1491 N004_53 A53 N009_53 N004_53 PMOS l=1u w=4u
M1492 N005_53 B53 N009_53 N005_53 PMOS l=1u w=4u
M1493 N006_53 C52 N009_53 N006_53 PMOS l=1u w=4u
M1494 N007_53 A53 N011_53 N007_53 PMOS l=1u w=8u
M1495 N011_53 B53 N017_53 N015_53 PMOS l=1u w=8u
M1496 N017_53 C52 N021_53 N018_53 PMOS l=1u w=8u
M1497 N021_53 C52 N022_53 0 NMOS l=1u w=8u
M1498 N022_53 B53 N026_53 0 NMOS l=1u w=8u
M1499 N026_53 A53 0 0 NMOS l=1u w=8u
M1500 N024_53 C52 0 0 NMOS l=1u w=2u
M1501 N024_53 B53 0 0 NMOS l=1u w=2u
M1502 N024_53 A53 0 0 NMOS l=1u w=2u
M1503 N021_53 N016_53 N024_53 0 NMOS l=1u w=2u
M1504 N023_53 B53 0 0 NMOS l=1u w=2u
M1505 N023_53 A53 0 0 NMOS l=1u w=2u
M1506 N025_53 A53 0 0 NMOS l=1u w=2u
M1507 N016_53 B53 N025_53 0 NMOS l=1u w=2u
M1508 N016_53 C52 N023_53 0 NMOS l=1u w=2u
M1509 C53 N016_53 0 0 NMOS l=1u w=1u
M1510 N009_53 N016_53 N021_53 N014_53 PMOS l=1u w=4u
M1511 N019_53 N021_53 SUM53 N019_53 PMOS l=1u w=2u
M1512 SUM53 N021_53 0 0 NMOS l=1u w=1u
R743 VDD N002_53 0.001
R744 VDD N003_53 0.001
R745 VDD N004_53 0.001
R746 VDD N005_53 0.001
R747 VDD N006_53 0.001
R748 VDD N007_53 0.001
R749 VDD N013_53 0.001
R750 N012_53 VDD 0.001
R751 VDD N001_53 0.001
R752 VDD N019_53 0.001
R753 VDD N014_53 0.001
R754 VDD N015_53 0.001
R755 VDD N018_53 0.001
R756 VDD N020_53 0.001
C107 SUM53 0 1p
C108 C53 0 1p

* Bit 54
M1513 N001_54 A54 N010_54 N001_54 PMOS l=1u w=4u
M1514 N010_54 B54 N016_54 N012_54 PMOS l=1u w=4u
M1515 N002_54 A54 N008_54 N002_54 PMOS l=1u w=4u
M1516 N008_54 C53 N016_54 N013_54 PMOS l=1u w=4u
M1517 N003_54 B54 N008_54 N003_54 PMOS l=1u w=4u
M1518 VDD N016_54 C54 N020_54 PMOS l=1u w=2u
M1519 N004_54 A54 N009_54 N004_54 PMOS l=1u w=4u
M1520 N005_54 B54 N009_54 N005_54 PMOS l=1u w=4u
M1521 N006_54 C53 N009_54 N006_54 PMOS l=1u w=4u
M1522 N007_54 A54 N011_54 N007_54 PMOS l=1u w=8u
M1523 N011_54 B54 N017_54 N015_54 PMOS l=1u w=8u
M1524 N017_54 C53 N021_54 N018_54 PMOS l=1u w=8u
M1525 N021_54 C53 N022_54 0 NMOS l=1u w=8u
M1526 N022_54 B54 N026_54 0 NMOS l=1u w=8u
M1527 N026_54 A54 0 0 NMOS l=1u w=8u
M1528 N024_54 C53 0 0 NMOS l=1u w=2u
M1529 N024_54 B54 0 0 NMOS l=1u w=2u
M1530 N024_54 A54 0 0 NMOS l=1u w=2u
M1531 N021_54 N016_54 N024_54 0 NMOS l=1u w=2u
M1532 N023_54 B54 0 0 NMOS l=1u w=2u
M1533 N023_54 A54 0 0 NMOS l=1u w=2u
M1534 N025_54 A54 0 0 NMOS l=1u w=2u
M1535 N016_54 B54 N025_54 0 NMOS l=1u w=2u
M1536 N016_54 C53 N023_54 0 NMOS l=1u w=2u
M1537 C54 N016_54 0 0 NMOS l=1u w=1u
M1538 N009_54 N016_54 N021_54 N014_54 PMOS l=1u w=4u
M1539 N019_54 N021_54 SUM54 N019_54 PMOS l=1u w=2u
M1540 SUM54 N021_54 0 0 NMOS l=1u w=1u
R757 VDD N002_54 0.001
R758 VDD N003_54 0.001
R759 VDD N004_54 0.001
R760 VDD N005_54 0.001
R761 VDD N006_54 0.001
R762 VDD N007_54 0.001
R763 VDD N013_54 0.001
R764 N012_54 VDD 0.001
R765 VDD N001_54 0.001
R766 VDD N019_54 0.001
R767 VDD N014_54 0.001
R768 VDD N015_54 0.001
R769 VDD N018_54 0.001
R770 VDD N020_54 0.001
C109 SUM54 0 1p
C110 C54 0 1p

* Bit 55
M1541 N001_55 A55 N010_55 N001_55 PMOS l=1u w=4u
M1542 N010_55 B55 N016_55 N012_55 PMOS l=1u w=4u
M1543 N002_55 A55 N008_55 N002_55 PMOS l=1u w=4u
M1544 N008_55 C54 N016_55 N013_55 PMOS l=1u w=4u
M1545 N003_55 B55 N008_55 N003_55 PMOS l=1u w=4u
M1546 VDD N016_55 C55 N020_55 PMOS l=1u w=2u
M1547 N004_55 A55 N009_55 N004_55 PMOS l=1u w=4u
M1548 N005_55 B55 N009_55 N005_55 PMOS l=1u w=4u
M1549 N006_55 C54 N009_55 N006_55 PMOS l=1u w=4u
M1550 N007_55 A55 N011_55 N007_55 PMOS l=1u w=8u
M1551 N011_55 B55 N017_55 N015_55 PMOS l=1u w=8u
M1552 N017_55 C54 N021_55 N018_55 PMOS l=1u w=8u
M1553 N021_55 C54 N022_55 0 NMOS l=1u w=8u
M1554 N022_55 B55 N026_55 0 NMOS l=1u w=8u
M1555 N026_55 A55 0 0 NMOS l=1u w=8u
M1556 N024_55 C54 0 0 NMOS l=1u w=2u
M1557 N024_55 B55 0 0 NMOS l=1u w=2u
M1558 N024_55 A55 0 0 NMOS l=1u w=2u
M1559 N021_55 N016_55 N024_55 0 NMOS l=1u w=2u
M1560 N023_55 B55 0 0 NMOS l=1u w=2u
M1561 N023_55 A55 0 0 NMOS l=1u w=2u
M1562 N025_55 A55 0 0 NMOS l=1u w=2u
M1563 N016_55 B55 N025_55 0 NMOS l=1u w=2u
M1564 N016_55 C54 N023_55 0 NMOS l=1u w=2u
M1565 C55 N016_55 0 0 NMOS l=1u w=1u
M1566 N009_55 N016_55 N021_55 N014_55 PMOS l=1u w=4u
M1567 N019_55 N021_55 SUM55 N019_55 PMOS l=1u w=2u
M1568 SUM55 N021_55 0 0 NMOS l=1u w=1u
R771 VDD N002_55 0.001
R772 VDD N003_55 0.001
R773 VDD N004_55 0.001
R774 VDD N005_55 0.001
R775 VDD N006_55 0.001
R776 VDD N007_55 0.001
R777 VDD N013_55 0.001
R778 N012_55 VDD 0.001
R779 VDD N001_55 0.001
R780 VDD N019_55 0.001
R781 VDD N014_55 0.001
R782 VDD N015_55 0.001
R783 VDD N018_55 0.001
R784 VDD N020_55 0.001
C111 SUM55 0 1p
C112 C55 0 1p

* Bit 56
M1569 N001_56 A56 N010_56 N001_56 PMOS l=1u w=4u
M1570 N010_56 B56 N016_56 N012_56 PMOS l=1u w=4u
M1571 N002_56 A56 N008_56 N002_56 PMOS l=1u w=4u
M1572 N008_56 C55 N016_56 N013_56 PMOS l=1u w=4u
M1573 N003_56 B56 N008_56 N003_56 PMOS l=1u w=4u
M1574 VDD N016_56 C56 N020_56 PMOS l=1u w=2u
M1575 N004_56 A56 N009_56 N004_56 PMOS l=1u w=4u
M1576 N005_56 B56 N009_56 N005_56 PMOS l=1u w=4u
M1577 N006_56 C55 N009_56 N006_56 PMOS l=1u w=4u
M1578 N007_56 A56 N011_56 N007_56 PMOS l=1u w=8u
M1579 N011_56 B56 N017_56 N015_56 PMOS l=1u w=8u
M1580 N017_56 C55 N021_56 N018_56 PMOS l=1u w=8u
M1581 N021_56 C55 N022_56 0 NMOS l=1u w=8u
M1582 N022_56 B56 N026_56 0 NMOS l=1u w=8u
M1583 N026_56 A56 0 0 NMOS l=1u w=8u
M1584 N024_56 C55 0 0 NMOS l=1u w=2u
M1585 N024_56 B56 0 0 NMOS l=1u w=2u
M1586 N024_56 A56 0 0 NMOS l=1u w=2u
M1587 N021_56 N016_56 N024_56 0 NMOS l=1u w=2u
M1588 N023_56 B56 0 0 NMOS l=1u w=2u
M1589 N023_56 A56 0 0 NMOS l=1u w=2u
M1590 N025_56 A56 0 0 NMOS l=1u w=2u
M1591 N016_56 B56 N025_56 0 NMOS l=1u w=2u
M1592 N016_56 C55 N023_56 0 NMOS l=1u w=2u
M1593 C56 N016_56 0 0 NMOS l=1u w=1u
M1594 N009_56 N016_56 N021_56 N014_56 PMOS l=1u w=4u
M1595 N019_56 N021_56 SUM56 N019_56 PMOS l=1u w=2u
M1596 SUM56 N021_56 0 0 NMOS l=1u w=1u
R785 VDD N002_56 0.001
R786 VDD N003_56 0.001
R787 VDD N004_56 0.001
R788 VDD N005_56 0.001
R789 VDD N006_56 0.001
R790 VDD N007_56 0.001
R791 VDD N013_56 0.001
R792 N012_56 VDD 0.001
R793 VDD N001_56 0.001
R794 VDD N019_56 0.001
R795 VDD N014_56 0.001
R796 VDD N015_56 0.001
R797 VDD N018_56 0.001
R798 VDD N020_56 0.001
C113 SUM56 0 1p
C114 C56 0 1p

* Bit 57
M1597 N001_57 A57 N010_57 N001_57 PMOS l=1u w=4u
M1598 N010_57 B57 N016_57 N012_57 PMOS l=1u w=4u
M1599 N002_57 A57 N008_57 N002_57 PMOS l=1u w=4u
M1600 N008_57 C56 N016_57 N013_57 PMOS l=1u w=4u
M1601 N003_57 B57 N008_57 N003_57 PMOS l=1u w=4u
M1602 VDD N016_57 C57 N020_57 PMOS l=1u w=2u
M1603 N004_57 A57 N009_57 N004_57 PMOS l=1u w=4u
M1604 N005_57 B57 N009_57 N005_57 PMOS l=1u w=4u
M1605 N006_57 C56 N009_57 N006_57 PMOS l=1u w=4u
M1606 N007_57 A57 N011_57 N007_57 PMOS l=1u w=8u
M1607 N011_57 B57 N017_57 N015_57 PMOS l=1u w=8u
M1608 N017_57 C56 N021_57 N018_57 PMOS l=1u w=8u
M1609 N021_57 C56 N022_57 0 NMOS l=1u w=8u
M1610 N022_57 B57 N026_57 0 NMOS l=1u w=8u
M1611 N026_57 A57 0 0 NMOS l=1u w=8u
M1612 N024_57 C56 0 0 NMOS l=1u w=2u
M1613 N024_57 B57 0 0 NMOS l=1u w=2u
M1614 N024_57 A57 0 0 NMOS l=1u w=2u
M1615 N021_57 N016_57 N024_57 0 NMOS l=1u w=2u
M1616 N023_57 B57 0 0 NMOS l=1u w=2u
M1617 N023_57 A57 0 0 NMOS l=1u w=2u
M1618 N025_57 A57 0 0 NMOS l=1u w=2u
M1619 N016_57 B57 N025_57 0 NMOS l=1u w=2u
M1620 N016_57 C56 N023_57 0 NMOS l=1u w=2u
M1621 C57 N016_57 0 0 NMOS l=1u w=1u
M1622 N009_57 N016_57 N021_57 N014_57 PMOS l=1u w=4u
M1623 N019_57 N021_57 SUM57 N019_57 PMOS l=1u w=2u
M1624 SUM57 N021_57 0 0 NMOS l=1u w=1u
R799 VDD N002_57 0.001
R800 VDD N003_57 0.001
R801 VDD N004_57 0.001
R802 VDD N005_57 0.001
R803 VDD N006_57 0.001
R804 VDD N007_57 0.001
R805 VDD N013_57 0.001
R806 N012_57 VDD 0.001
R807 VDD N001_57 0.001
R808 VDD N019_57 0.001
R809 VDD N014_57 0.001
R810 VDD N015_57 0.001
R811 VDD N018_57 0.001
R812 VDD N020_57 0.001
C115 SUM57 0 1p
C116 C57 0 1p

* Bit 58
M1625 N001_58 A58 N010_58 N001_58 PMOS l=1u w=4u
M1626 N010_58 B58 N016_58 N012_58 PMOS l=1u w=4u
M1627 N002_58 A58 N008_58 N002_58 PMOS l=1u w=4u
M1628 N008_58 C57 N016_58 N013_58 PMOS l=1u w=4u
M1629 N003_58 B58 N008_58 N003_58 PMOS l=1u w=4u
M1630 VDD N016_58 C58 N020_58 PMOS l=1u w=2u
M1631 N004_58 A58 N009_58 N004_58 PMOS l=1u w=4u
M1632 N005_58 B58 N009_58 N005_58 PMOS l=1u w=4u
M1633 N006_58 C57 N009_58 N006_58 PMOS l=1u w=4u
M1634 N007_58 A58 N011_58 N007_58 PMOS l=1u w=8u
M1635 N011_58 B58 N017_58 N015_58 PMOS l=1u w=8u
M1636 N017_58 C57 N021_58 N018_58 PMOS l=1u w=8u
M1637 N021_58 C57 N022_58 0 NMOS l=1u w=8u
M1638 N022_58 B58 N026_58 0 NMOS l=1u w=8u
M1639 N026_58 A58 0 0 NMOS l=1u w=8u
M1640 N024_58 C57 0 0 NMOS l=1u w=2u
M1641 N024_58 B58 0 0 NMOS l=1u w=2u
M1642 N024_58 A58 0 0 NMOS l=1u w=2u
M1643 N021_58 N016_58 N024_58 0 NMOS l=1u w=2u
M1644 N023_58 B58 0 0 NMOS l=1u w=2u
M1645 N023_58 A58 0 0 NMOS l=1u w=2u
M1646 N025_58 A58 0 0 NMOS l=1u w=2u
M1647 N016_58 B58 N025_58 0 NMOS l=1u w=2u
M1648 N016_58 C57 N023_58 0 NMOS l=1u w=2u
M1649 C58 N016_58 0 0 NMOS l=1u w=1u
M1650 N009_58 N016_58 N021_58 N014_58 PMOS l=1u w=4u
M1651 N019_58 N021_58 SUM58 N019_58 PMOS l=1u w=2u
M1652 SUM58 N021_58 0 0 NMOS l=1u w=1u
R813 VDD N002_58 0.001
R814 VDD N003_58 0.001
R815 VDD N004_58 0.001
R816 VDD N005_58 0.001
R817 VDD N006_58 0.001
R818 VDD N007_58 0.001
R819 VDD N013_58 0.001
R820 N012_58 VDD 0.001
R821 VDD N001_58 0.001
R822 VDD N019_58 0.001
R823 VDD N014_58 0.001
R824 VDD N015_58 0.001
R825 VDD N018_58 0.001
R826 VDD N020_58 0.001
C117 SUM58 0 1p
C118 C58 0 1p

* Bit 59
M1653 N001_59 A59 N010_59 N001_59 PMOS l=1u w=4u
M1654 N010_59 B59 N016_59 N012_59 PMOS l=1u w=4u
M1655 N002_59 A59 N008_59 N002_59 PMOS l=1u w=4u
M1656 N008_59 C58 N016_59 N013_59 PMOS l=1u w=4u
M1657 N003_59 B59 N008_59 N003_59 PMOS l=1u w=4u
M1658 VDD N016_59 C59 N020_59 PMOS l=1u w=2u
M1659 N004_59 A59 N009_59 N004_59 PMOS l=1u w=4u
M1660 N005_59 B59 N009_59 N005_59 PMOS l=1u w=4u
M1661 N006_59 C58 N009_59 N006_59 PMOS l=1u w=4u
M1662 N007_59 A59 N011_59 N007_59 PMOS l=1u w=8u
M1663 N011_59 B59 N017_59 N015_59 PMOS l=1u w=8u
M1664 N017_59 C58 N021_59 N018_59 PMOS l=1u w=8u
M1665 N021_59 C58 N022_59 0 NMOS l=1u w=8u
M1666 N022_59 B59 N026_59 0 NMOS l=1u w=8u
M1667 N026_59 A59 0 0 NMOS l=1u w=8u
M1668 N024_59 C58 0 0 NMOS l=1u w=2u
M1669 N024_59 B59 0 0 NMOS l=1u w=2u
M1670 N024_59 A59 0 0 NMOS l=1u w=2u
M1671 N021_59 N016_59 N024_59 0 NMOS l=1u w=2u
M1672 N023_59 B59 0 0 NMOS l=1u w=2u
M1673 N023_59 A59 0 0 NMOS l=1u w=2u
M1674 N025_59 A59 0 0 NMOS l=1u w=2u
M1675 N016_59 B59 N025_59 0 NMOS l=1u w=2u
M1676 N016_59 C58 N023_59 0 NMOS l=1u w=2u
M1677 C59 N016_59 0 0 NMOS l=1u w=1u
M1678 N009_59 N016_59 N021_59 N014_59 PMOS l=1u w=4u
M1679 N019_59 N021_59 SUM59 N019_59 PMOS l=1u w=2u
M1680 SUM59 N021_59 0 0 NMOS l=1u w=1u
R827 VDD N002_59 0.001
R828 VDD N003_59 0.001
R829 VDD N004_59 0.001
R830 VDD N005_59 0.001
R831 VDD N006_59 0.001
R832 VDD N007_59 0.001
R833 VDD N013_59 0.001
R834 N012_59 VDD 0.001
R835 VDD N001_59 0.001
R836 VDD N019_59 0.001
R837 VDD N014_59 0.001
R838 VDD N015_59 0.001
R839 VDD N018_59 0.001
R840 VDD N020_59 0.001
C119 SUM59 0 1p
C120 C59 0 1p

* Bit 60
M1681 N001_60 A60 N010_60 N001_60 PMOS l=1u w=4u
M1682 N010_60 B60 N016_60 N012_60 PMOS l=1u w=4u
M1683 N002_60 A60 N008_60 N002_60 PMOS l=1u w=4u
M1684 N008_60 C59 N016_60 N013_60 PMOS l=1u w=4u
M1685 N003_60 B60 N008_60 N003_60 PMOS l=1u w=4u
M1686 VDD N016_60 C60 N020_60 PMOS l=1u w=2u
M1687 N004_60 A60 N009_60 N004_60 PMOS l=1u w=4u
M1688 N005_60 B60 N009_60 N005_60 PMOS l=1u w=4u
M1689 N006_60 C59 N009_60 N006_60 PMOS l=1u w=4u
M1690 N007_60 A60 N011_60 N007_60 PMOS l=1u w=8u
M1691 N011_60 B60 N017_60 N015_60 PMOS l=1u w=8u
M1692 N017_60 C59 N021_60 N018_60 PMOS l=1u w=8u
M1693 N021_60 C59 N022_60 0 NMOS l=1u w=8u
M1694 N022_60 B60 N026_60 0 NMOS l=1u w=8u
M1695 N026_60 A60 0 0 NMOS l=1u w=8u
M1696 N024_60 C59 0 0 NMOS l=1u w=2u
M1697 N024_60 B60 0 0 NMOS l=1u w=2u
M1698 N024_60 A60 0 0 NMOS l=1u w=2u
M1699 N021_60 N016_60 N024_60 0 NMOS l=1u w=2u
M1700 N023_60 B60 0 0 NMOS l=1u w=2u
M1701 N023_60 A60 0 0 NMOS l=1u w=2u
M1702 N025_60 A60 0 0 NMOS l=1u w=2u
M1703 N016_60 B60 N025_60 0 NMOS l=1u w=2u
M1704 N016_60 C59 N023_60 0 NMOS l=1u w=2u
M1705 C60 N016_60 0 0 NMOS l=1u w=1u
M1706 N009_60 N016_60 N021_60 N014_60 PMOS l=1u w=4u
M1707 N019_60 N021_60 SUM60 N019_60 PMOS l=1u w=2u
M1708 SUM60 N021_60 0 0 NMOS l=1u w=1u
R841 VDD N002_60 0.001
R842 VDD N003_60 0.001
R843 VDD N004_60 0.001
R844 VDD N005_60 0.001
R845 VDD N006_60 0.001
R846 VDD N007_60 0.001
R847 VDD N013_60 0.001
R848 N012_60 VDD 0.001
R849 VDD N001_60 0.001
R850 VDD N019_60 0.001
R851 VDD N014_60 0.001
R852 VDD N015_60 0.001
R853 VDD N018_60 0.001
R854 VDD N020_60 0.001
C121 SUM60 0 1p
C122 C60 0 1p

* Bit 61
M1709 N001_61 A61 N010_61 N001_61 PMOS l=1u w=4u
M1710 N010_61 B61 N016_61 N012_61 PMOS l=1u w=4u
M1711 N002_61 A61 N008_61 N002_61 PMOS l=1u w=4u
M1712 N008_61 C60 N016_61 N013_61 PMOS l=1u w=4u
M1713 N003_61 B61 N008_61 N003_61 PMOS l=1u w=4u
M1714 VDD N016_61 C61 N020_61 PMOS l=1u w=2u
M1715 N004_61 A61 N009_61 N004_61 PMOS l=1u w=4u
M1716 N005_61 B61 N009_61 N005_61 PMOS l=1u w=4u
M1717 N006_61 C60 N009_61 N006_61 PMOS l=1u w=4u
M1718 N007_61 A61 N011_61 N007_61 PMOS l=1u w=8u
M1719 N011_61 B61 N017_61 N015_61 PMOS l=1u w=8u
M1720 N017_61 C60 N021_61 N018_61 PMOS l=1u w=8u
M1721 N021_61 C60 N022_61 0 NMOS l=1u w=8u
M1722 N022_61 B61 N026_61 0 NMOS l=1u w=8u
M1723 N026_61 A61 0 0 NMOS l=1u w=8u
M1724 N024_61 C60 0 0 NMOS l=1u w=2u
M1725 N024_61 B61 0 0 NMOS l=1u w=2u
M1726 N024_61 A61 0 0 NMOS l=1u w=2u
M1727 N021_61 N016_61 N024_61 0 NMOS l=1u w=2u
M1728 N023_61 B61 0 0 NMOS l=1u w=2u
M1729 N023_61 A61 0 0 NMOS l=1u w=2u
M1730 N025_61 A61 0 0 NMOS l=1u w=2u
M1731 N016_61 B61 N025_61 0 NMOS l=1u w=2u
M1732 N016_61 C60 N023_61 0 NMOS l=1u w=2u
M1733 C61 N016_61 0 0 NMOS l=1u w=1u
M1734 N009_61 N016_61 N021_61 N014_61 PMOS l=1u w=4u
M1735 N019_61 N021_61 SUM61 N019_61 PMOS l=1u w=2u
M1736 SUM61 N021_61 0 0 NMOS l=1u w=1u
R855 VDD N002_61 0.001
R856 VDD N003_61 0.001
R857 VDD N004_61 0.001
R858 VDD N005_61 0.001
R859 VDD N006_61 0.001
R860 VDD N007_61 0.001
R861 VDD N013_61 0.001
R862 N012_61 VDD 0.001
R863 VDD N001_61 0.001
R864 VDD N019_61 0.001
R865 VDD N014_61 0.001
R866 VDD N015_61 0.001
R867 VDD N018_61 0.001
R868 VDD N020_61 0.001
C123 SUM61 0 1p
C124 C61 0 1p

* Bit 62
M1737 N001_62 A62 N010_62 N001_62 PMOS l=1u w=4u
M1738 N010_62 B62 N016_62 N012_62 PMOS l=1u w=4u
M1739 N002_62 A62 N008_62 N002_62 PMOS l=1u w=4u
M1740 N008_62 C61 N016_62 N013_62 PMOS l=1u w=4u
M1741 N003_62 B62 N008_62 N003_62 PMOS l=1u w=4u
M1742 VDD N016_62 C62 N020_62 PMOS l=1u w=2u
M1743 N004_62 A62 N009_62 N004_62 PMOS l=1u w=4u
M1744 N005_62 B62 N009_62 N005_62 PMOS l=1u w=4u
M1745 N006_62 C61 N009_62 N006_62 PMOS l=1u w=4u
M1746 N007_62 A62 N011_62 N007_62 PMOS l=1u w=8u
M1747 N011_62 B62 N017_62 N015_62 PMOS l=1u w=8u
M1748 N017_62 C61 N021_62 N018_62 PMOS l=1u w=8u
M1749 N021_62 C61 N022_62 0 NMOS l=1u w=8u
M1750 N022_62 B62 N026_62 0 NMOS l=1u w=8u
M1751 N026_62 A62 0 0 NMOS l=1u w=8u
M1752 N024_62 C61 0 0 NMOS l=1u w=2u
M1753 N024_62 B62 0 0 NMOS l=1u w=2u
M1754 N024_62 A62 0 0 NMOS l=1u w=2u
M1755 N021_62 N016_62 N024_62 0 NMOS l=1u w=2u
M1756 N023_62 B62 0 0 NMOS l=1u w=2u
M1757 N023_62 A62 0 0 NMOS l=1u w=2u
M1758 N025_62 A62 0 0 NMOS l=1u w=2u
M1759 N016_62 B62 N025_62 0 NMOS l=1u w=2u
M1760 N016_62 C61 N023_62 0 NMOS l=1u w=2u
M1761 C62 N016_62 0 0 NMOS l=1u w=1u
M1762 N009_62 N016_62 N021_62 N014_62 PMOS l=1u w=4u
M1763 N019_62 N021_62 SUM62 N019_62 PMOS l=1u w=2u
M1764 SUM62 N021_62 0 0 NMOS l=1u w=1u
R869 VDD N002_62 0.001
R870 VDD N003_62 0.001
R871 VDD N004_62 0.001
R872 VDD N005_62 0.001
R873 VDD N006_62 0.001
R874 VDD N007_62 0.001
R875 VDD N013_62 0.001
R876 N012_62 VDD 0.001
R877 VDD N001_62 0.001
R878 VDD N019_62 0.001
R879 VDD N014_62 0.001
R880 VDD N015_62 0.001
R881 VDD N018_62 0.001
R882 VDD N020_62 0.001
C125 SUM62 0 1p
C126 C62 0 1p

* Bit 63
M1765 N001_63 A63 N010_63 N001_63 PMOS l=1u w=4u
M1766 N010_63 B63 N016_63 N012_63 PMOS l=1u w=4u
M1767 N002_63 A63 N008_63 N002_63 PMOS l=1u w=4u
M1768 N008_63 C62 N016_63 N013_63 PMOS l=1u w=4u
M1769 N003_63 B63 N008_63 N003_63 PMOS l=1u w=4u
M1770 VDD N016_63 C63 N020_63 PMOS l=1u w=2u
M1771 N004_63 A63 N009_63 N004_63 PMOS l=1u w=4u
M1772 N005_63 B63 N009_63 N005_63 PMOS l=1u w=4u
M1773 N006_63 C62 N009_63 N006_63 PMOS l=1u w=4u
M1774 N007_63 A63 N011_63 N007_63 PMOS l=1u w=8u
M1775 N011_63 B63 N017_63 N015_63 PMOS l=1u w=8u
M1776 N017_63 C62 N021_63 N018_63 PMOS l=1u w=8u
M1777 N021_63 C62 N022_63 0 NMOS l=1u w=8u
M1778 N022_63 B63 N026_63 0 NMOS l=1u w=8u
M1779 N026_63 A63 0 0 NMOS l=1u w=8u
M1780 N024_63 C62 0 0 NMOS l=1u w=2u
M1781 N024_63 B63 0 0 NMOS l=1u w=2u
M1782 N024_63 A63 0 0 NMOS l=1u w=2u
M1783 N021_63 N016_63 N024_63 0 NMOS l=1u w=2u
M1784 N023_63 B63 0 0 NMOS l=1u w=2u
M1785 N023_63 A63 0 0 NMOS l=1u w=2u
M1786 N025_63 A63 0 0 NMOS l=1u w=2u
M1787 N016_63 B63 N025_63 0 NMOS l=1u w=2u
M1788 N016_63 C62 N023_63 0 NMOS l=1u w=2u
M1789 C63 N016_63 0 0 NMOS l=1u w=1u
M1790 N009_63 N016_63 N021_63 N014_63 PMOS l=1u w=4u
M1791 N019_63 N021_63 SUM63 N019_63 PMOS l=1u w=2u
M1792 SUM63 N021_63 0 0 NMOS l=1u w=1u
R883 VDD N002_63 0.001
R884 VDD N003_63 0.001
R885 VDD N004_63 0.001
R886 VDD N005_63 0.001
R887 VDD N006_63 0.001
R888 VDD N007_63 0.001
R889 VDD N013_63 0.001
R890 N012_63 VDD 0.001
R891 VDD N001_63 0.001
R892 VDD N019_63 0.001
R893 VDD N014_63 0.001
R894 VDD N015_63 0.001
R895 VDD N018_63 0.001
R896 VDD N020_63 0.001
C127 SUM63 0 1p
C128 C63 0 1p

* --- Input Stimuli (Initialized to 0V) ---
* Modify these lines or use a separate file to drive inputs
V_Cin Cin 0 0
V_A0 A0 0 1.8
V_B0 B0 0 1.8
V_A1 A1 0 0
V_B1 B1 0 0
V_A2 A2 0 0
V_B2 B2 0 0
V_A3 A3 0 1.8
V_B3 B3 0 1.8
V_A4 A4 0 0
V_B4 B4 0 0
V_A5 A5 0 0
V_B5 B5 0 0
V_A6 A6 0 0
V_B6 B6 0 0
V_A7 A7 0 0
V_B7 B7 0 1.8
V_A8 A8 0 0
V_B8 B8 0 0
V_A9 A9 0 0
V_B9 B9 0 0
V_A10 A10 0 0
V_B10 B10 0 0
V_A11 A11 0 0
V_B11 B11 0 0
V_A12 A12 0 1.8
V_B12 B12 0 0
V_A13 A13 0 0
V_B13 B13 0 0
V_A14 A14 0 0
V_B14 B14 0 1.8
V_A15 A15 0 0
V_B15 B15 0 0
V_A16 A16 0 0
V_B16 B16 0 0
V_A17 A17 0 0
V_B17 B17 0 1.8
V_A18 A18 0 0
V_B18 B18 0 0
V_A19 A19 0 0
V_B19 B19 0 1.8
V_A20 A20 0 0
V_B20 B20 0 0
V_A21 A21 0 0
V_B21 B21 0 0
V_A22 A22 0 0
V_B22 B22 0 0
V_A23 A23 0 0
V_B23 B23 0 1.8
V_A24 A24 0 0
V_B24 B24 0 0
V_A25 A25 0 0
V_B25 B25 0 0
V_A26 A26 0 1.8
V_B26 B26 0 0
V_A27 A27 0 0
V_B27 B27 0 0
V_A28 A28 0 0
V_B28 B28 0 0
V_A29 A29 0 0
V_B29 B29 0 0
V_A30 A30 0 1.8
V_B30 B30 0 1.8
V_A31 A31 0 0
V_B31 B31 0 0
V_A32 A32 0 0
V_B32 B32 0 0
V_A33 A33 0 1.8
V_B33 B33 0 0
V_A34 A34 0 0
V_B34 B34 0 0
V_A35 A35 0 0
V_B35 B35 0 0
V_A36 A36 0 0
V_B36 B36 0 1.8
V_A37 A37 0 0
V_B37 B37 0 0
V_A38 A38 0 0
V_B38 B38 0 0
V_A39 A39 0 0
V_B39 B39 0 0
V_A40 A40 0 0
V_B40 B40 0 0
V_A41 A41 0 0
V_B41 B41 0 0
V_A42 A42 0 1.8
V_B42 B42 0 0
V_A43 A43 0 0
V_B43 B43 0 0
V_A44 A44 0 0
V_B44 B44 0 0
V_A45 A45 0 0
V_B45 B45 0 0
V_A46 A46 0 0
V_B46 B46 0 0
V_A47 A47 0 1.8
V_B47 B47 0 0
V_A48 A48 0 0
V_B48 B48 0 0
V_A49 A49 0 0
V_B49 B49 0 0
V_A50 A50 0 0
V_B50 B50 0 0
V_A51 A51 0 1.8
V_B51 B51 0 0
V_A52 A52 0 0
V_B52 B52 0 0
V_A53 A53 0 0
V_B53 B53 0 0
V_A54 A54 0 0
V_B54 B54 0 0
V_A55 A55 0 1.8
V_B55 B55 0 0
V_A56 A56 0 0
V_B56 B56 0 0
V_A57 A57 0 0
V_B57 B57 0 0
V_A58 A58 0 0
V_B58 B58 0 1.8
V_A59 A59 0 0
V_B59 B59 0 0
V_A60 A60 0 0
V_B60 B60 0 0
V_A61 A61 0 0
V_B61 B61 0 0
V_A62 A62 0 0
V_B62 B62 0 0
V_A63 A63 0 1.8
V_B63 B63 0 0

.tran 2u 50000u

.end
