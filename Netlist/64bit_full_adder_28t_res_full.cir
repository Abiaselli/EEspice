* 64-bit Full Adder Netlist
* Generated file: 64bit_adder.txt
* Isolation Resistor = 0.01 ohm added to all non-ground nodes

* Models
.model nmos nmos (level=14 version=4.8.2)
.model pmos pmos (level=14 version=4.8.2)

* Simulation flags
.options acct
*.options num_threads=32
.sparse
.output Results/64bit_full_adder_28t_res_full.raw

* --- Bit 0 ---
R_VDD_M1_0_d VDD VDD_M1_0_d 0.01
R_A_0_M1_0_g A_0 A_0_M1_0_g 0.01
R_N003_0_M1_0_s N003_0 N003_0_M1_0_s 0.01
R_VDD_M1_0_b VDD VDD_M1_0_b 0.01
M1_0 VDD_M1_0_d A_0_M1_0_g N003_0_M1_0_s VDD_M1_0_b pmos l=1u w=4u
R_N003_0_M2_0_d N003_0 N003_0_M2_0_d 0.01
R_B_0_M2_0_g B_0 B_0_M2_0_g 0.01
R_N005_0_M2_0_s N005_0 N005_0_M2_0_s 0.01
R_VDD_M2_0_b VDD VDD_M2_0_b 0.01
M2_0 N003_0_M2_0_d B_0_M2_0_g N005_0_M2_0_s VDD_M2_0_b pmos l=1u w=4u
R_VDD_M3_0_d VDD VDD_M3_0_d 0.01
R_A_0_M3_0_g A_0 A_0_M3_0_g 0.01
R_N001_0_M3_0_s N001_0 N001_0_M3_0_s 0.01
R_VDD_M3_0_b VDD VDD_M3_0_b 0.01
M3_0 VDD_M3_0_d A_0_M3_0_g N001_0_M3_0_s VDD_M3_0_b pmos l=1u w=4u
R_N001_0_M4_0_d N001_0 N001_0_M4_0_d 0.01
R_C_0_M4_0_g C_0 C_0_M4_0_g 0.01
R_N005_0_M4_0_s N005_0 N005_0_M4_0_s 0.01
R_VDD_M4_0_b VDD VDD_M4_0_b 0.01
M4_0 N001_0_M4_0_d C_0_M4_0_g N005_0_M4_0_s VDD_M4_0_b pmos l=1u w=4u
R_VDD_M5_0_d VDD VDD_M5_0_d 0.01
R_B_0_M5_0_g B_0 B_0_M5_0_g 0.01
R_N001_0_M5_0_s N001_0 N001_0_M5_0_s 0.01
R_VDD_M5_0_b VDD VDD_M5_0_b 0.01
M5_0 VDD_M5_0_d B_0_M5_0_g N001_0_M5_0_s VDD_M5_0_b pmos l=1u w=4u
R_VDD_M6_0_d VDD VDD_M6_0_d 0.01
R_N005_0_M6_0_g N005_0 N005_0_M6_0_g 0.01
R_C_1_M6_0_s C_1 C_1_M6_0_s 0.01
R_VDD_M6_0_b VDD VDD_M6_0_b 0.01
M6_0 VDD_M6_0_d N005_0_M6_0_g C_1_M6_0_s VDD_M6_0_b pmos l=1u w=2u
R_VDD_M7_0_d VDD VDD_M7_0_d 0.01
R_A_0_M7_0_g A_0 A_0_M7_0_g 0.01
R_N002_0_M7_0_s N002_0 N002_0_M7_0_s 0.01
R_VDD_M7_0_b VDD VDD_M7_0_b 0.01
M7_0 VDD_M7_0_d A_0_M7_0_g N002_0_M7_0_s VDD_M7_0_b pmos l=1u w=4u
R_VDD_M8_0_d VDD VDD_M8_0_d 0.01
R_B_0_M8_0_g B_0 B_0_M8_0_g 0.01
R_N002_0_M8_0_s N002_0 N002_0_M8_0_s 0.01
R_VDD_M8_0_b VDD VDD_M8_0_b 0.01
M8_0 VDD_M8_0_d B_0_M8_0_g N002_0_M8_0_s VDD_M8_0_b pmos l=1u w=4u
R_VDD_M9_0_d VDD VDD_M9_0_d 0.01
R_C_0_M9_0_g C_0 C_0_M9_0_g 0.01
R_N002_0_M9_0_s N002_0 N002_0_M9_0_s 0.01
R_VDD_M9_0_b VDD VDD_M9_0_b 0.01
M9_0 VDD_M9_0_d C_0_M9_0_g N002_0_M9_0_s VDD_M9_0_b pmos l=1u w=4u
R_VDD_M10_0_d VDD VDD_M10_0_d 0.01
R_A_0_M10_0_g A_0 A_0_M10_0_g 0.01
R_N004_0_M10_0_s N004_0 N004_0_M10_0_s 0.01
R_VDD_M10_0_b VDD VDD_M10_0_b 0.01
M10_0 VDD_M10_0_d A_0_M10_0_g N004_0_M10_0_s VDD_M10_0_b pmos l=1u w=8u
R_N004_0_M11_0_d N004_0 N004_0_M11_0_d 0.01
R_B_0_M11_0_g B_0 B_0_M11_0_g 0.01
R_N006_0_M11_0_s N006_0 N006_0_M11_0_s 0.01
R_VDD_M11_0_b VDD VDD_M11_0_b 0.01
M11_0 N004_0_M11_0_d B_0_M11_0_g N006_0_M11_0_s VDD_M11_0_b pmos l=1u w=8u
R_N006_0_M12_0_d N006_0 N006_0_M12_0_d 0.01
R_C_0_M12_0_g C_0 C_0_M12_0_g 0.01
R_N007_0_M12_0_s N007_0 N007_0_M12_0_s 0.01
R_VDD_M12_0_b VDD VDD_M12_0_b 0.01
M12_0 N006_0_M12_0_d C_0_M12_0_g N007_0_M12_0_s VDD_M12_0_b pmos l=1u w=8u
R_N007_0_M13_0_d N007_0 N007_0_M13_0_d 0.01
R_C_0_M13_0_g C_0 C_0_M13_0_g 0.01
R_N008_0_M13_0_s N008_0 N008_0_M13_0_s 0.01
M13_0 N007_0_M13_0_d C_0_M13_0_g N008_0_M13_0_s 0 nmos l=1u w=8u
R_N008_0_M14_0_d N008_0 N008_0_M14_0_d 0.01
R_B_0_M14_0_g B_0 B_0_M14_0_g 0.01
R_N012_0_M14_0_s N012_0 N012_0_M14_0_s 0.01
M14_0 N008_0_M14_0_d B_0_M14_0_g N012_0_M14_0_s 0 nmos l=1u w=8u
R_N012_0_M15_0_d N012_0 N012_0_M15_0_d 0.01
R_A_0_M15_0_g A_0 A_0_M15_0_g 0.01
M15_0 N012_0_M15_0_d A_0_M15_0_g 0 0 nmos l=1u w=8u
R_N010_0_M16_0_d N010_0 N010_0_M16_0_d 0.01
R_C_0_M16_0_g C_0 C_0_M16_0_g 0.01
M16_0 N010_0_M16_0_d C_0_M16_0_g 0 0 nmos l=1u w=2u
R_N010_0_M17_0_d N010_0 N010_0_M17_0_d 0.01
R_B_0_M17_0_g B_0 B_0_M17_0_g 0.01
M17_0 N010_0_M17_0_d B_0_M17_0_g 0 0 nmos l=1u w=2u
R_N010_0_M18_0_d N010_0 N010_0_M18_0_d 0.01
R_A_0_M18_0_g A_0 A_0_M18_0_g 0.01
M18_0 N010_0_M18_0_d A_0_M18_0_g 0 0 nmos l=1u w=2u
R_N007_0_M19_0_d N007_0 N007_0_M19_0_d 0.01
R_N005_0_M19_0_g N005_0 N005_0_M19_0_g 0.01
R_N010_0_M19_0_s N010_0 N010_0_M19_0_s 0.01
M19_0 N007_0_M19_0_d N005_0_M19_0_g N010_0_M19_0_s 0 nmos l=1u w=2u
R_N009_0_M20_0_d N009_0 N009_0_M20_0_d 0.01
R_B_0_M20_0_g B_0 B_0_M20_0_g 0.01
M20_0 N009_0_M20_0_d B_0_M20_0_g 0 0 nmos l=1u w=2u
R_N009_0_M21_0_d N009_0 N009_0_M21_0_d 0.01
R_A_0_M21_0_g A_0 A_0_M21_0_g 0.01
M21_0 N009_0_M21_0_d A_0_M21_0_g 0 0 nmos l=1u w=2u
R_N011_0_M22_0_d N011_0 N011_0_M22_0_d 0.01
R_A_0_M22_0_g A_0 A_0_M22_0_g 0.01
M22_0 N011_0_M22_0_d A_0_M22_0_g 0 0 nmos l=1u w=2u
R_N005_0_M23_0_d N005_0 N005_0_M23_0_d 0.01
R_B_0_M23_0_g B_0 B_0_M23_0_g 0.01
R_N011_0_M23_0_s N011_0 N011_0_M23_0_s 0.01
M23_0 N005_0_M23_0_d B_0_M23_0_g N011_0_M23_0_s 0 nmos l=1u w=2u
R_N005_0_M24_0_d N005_0 N005_0_M24_0_d 0.01
R_C_0_M24_0_g C_0 C_0_M24_0_g 0.01
R_N009_0_M24_0_s N009_0 N009_0_M24_0_s 0.01
M24_0 N005_0_M24_0_d C_0_M24_0_g N009_0_M24_0_s 0 nmos l=1u w=2u
R_C_1_M25_0_d C_1 C_1_M25_0_d 0.01
R_N005_0_M25_0_g N005_0 N005_0_M25_0_g 0.01
M25_0 C_1_M25_0_d N005_0_M25_0_g 0 0 nmos l=1u w=1u
R_N002_0_M26_0_d N002_0 N002_0_M26_0_d 0.01
R_N005_0_M26_0_g N005_0 N005_0_M26_0_g 0.01
R_N007_0_M26_0_s N007_0 N007_0_M26_0_s 0.01
R_VDD_M26_0_b VDD VDD_M26_0_b 0.01
M26_0 N002_0_M26_0_d N005_0_M26_0_g N007_0_M26_0_s VDD_M26_0_b pmos l=1u w=4u
R_VDD_M27_0_d VDD VDD_M27_0_d 0.01
R_N007_0_M27_0_g N007_0 N007_0_M27_0_g 0.01
R_S_0_M27_0_s S_0 S_0_M27_0_s 0.01
R_VDD_M27_0_b VDD VDD_M27_0_b 0.01
M27_0 VDD_M27_0_d N007_0_M27_0_g S_0_M27_0_s VDD_M27_0_b pmos l=1u w=2u
R_S_0_M28_0_d S_0 S_0_M28_0_d 0.01
R_N007_0_M28_0_g N007_0 N007_0_M28_0_g 0.01
M28_0 S_0_M28_0_d N007_0_M28_0_g 0 0 nmos l=1u w=1u
C_S_0 S_0 0 1f
* --- Bit 1 ---
R_VDD_M1_1_d VDD VDD_M1_1_d 0.01
R_A_1_M1_1_g A_1 A_1_M1_1_g 0.01
R_N003_1_M1_1_s N003_1 N003_1_M1_1_s 0.01
R_VDD_M1_1_b VDD VDD_M1_1_b 0.01
M1_1 VDD_M1_1_d A_1_M1_1_g N003_1_M1_1_s VDD_M1_1_b pmos l=1u w=4u
R_N003_1_M2_1_d N003_1 N003_1_M2_1_d 0.01
R_B_1_M2_1_g B_1 B_1_M2_1_g 0.01
R_N005_1_M2_1_s N005_1 N005_1_M2_1_s 0.01
R_VDD_M2_1_b VDD VDD_M2_1_b 0.01
M2_1 N003_1_M2_1_d B_1_M2_1_g N005_1_M2_1_s VDD_M2_1_b pmos l=1u w=4u
R_VDD_M3_1_d VDD VDD_M3_1_d 0.01
R_A_1_M3_1_g A_1 A_1_M3_1_g 0.01
R_N001_1_M3_1_s N001_1 N001_1_M3_1_s 0.01
R_VDD_M3_1_b VDD VDD_M3_1_b 0.01
M3_1 VDD_M3_1_d A_1_M3_1_g N001_1_M3_1_s VDD_M3_1_b pmos l=1u w=4u
R_N001_1_M4_1_d N001_1 N001_1_M4_1_d 0.01
R_C_1_M4_1_g C_1 C_1_M4_1_g 0.01
R_N005_1_M4_1_s N005_1 N005_1_M4_1_s 0.01
R_VDD_M4_1_b VDD VDD_M4_1_b 0.01
M4_1 N001_1_M4_1_d C_1_M4_1_g N005_1_M4_1_s VDD_M4_1_b pmos l=1u w=4u
R_VDD_M5_1_d VDD VDD_M5_1_d 0.01
R_B_1_M5_1_g B_1 B_1_M5_1_g 0.01
R_N001_1_M5_1_s N001_1 N001_1_M5_1_s 0.01
R_VDD_M5_1_b VDD VDD_M5_1_b 0.01
M5_1 VDD_M5_1_d B_1_M5_1_g N001_1_M5_1_s VDD_M5_1_b pmos l=1u w=4u
R_VDD_M6_1_d VDD VDD_M6_1_d 0.01
R_N005_1_M6_1_g N005_1 N005_1_M6_1_g 0.01
R_C_2_M6_1_s C_2 C_2_M6_1_s 0.01
R_VDD_M6_1_b VDD VDD_M6_1_b 0.01
M6_1 VDD_M6_1_d N005_1_M6_1_g C_2_M6_1_s VDD_M6_1_b pmos l=1u w=2u
R_VDD_M7_1_d VDD VDD_M7_1_d 0.01
R_A_1_M7_1_g A_1 A_1_M7_1_g 0.01
R_N002_1_M7_1_s N002_1 N002_1_M7_1_s 0.01
R_VDD_M7_1_b VDD VDD_M7_1_b 0.01
M7_1 VDD_M7_1_d A_1_M7_1_g N002_1_M7_1_s VDD_M7_1_b pmos l=1u w=4u
R_VDD_M8_1_d VDD VDD_M8_1_d 0.01
R_B_1_M8_1_g B_1 B_1_M8_1_g 0.01
R_N002_1_M8_1_s N002_1 N002_1_M8_1_s 0.01
R_VDD_M8_1_b VDD VDD_M8_1_b 0.01
M8_1 VDD_M8_1_d B_1_M8_1_g N002_1_M8_1_s VDD_M8_1_b pmos l=1u w=4u
R_VDD_M9_1_d VDD VDD_M9_1_d 0.01
R_C_1_M9_1_g C_1 C_1_M9_1_g 0.01
R_N002_1_M9_1_s N002_1 N002_1_M9_1_s 0.01
R_VDD_M9_1_b VDD VDD_M9_1_b 0.01
M9_1 VDD_M9_1_d C_1_M9_1_g N002_1_M9_1_s VDD_M9_1_b pmos l=1u w=4u
R_VDD_M10_1_d VDD VDD_M10_1_d 0.01
R_A_1_M10_1_g A_1 A_1_M10_1_g 0.01
R_N004_1_M10_1_s N004_1 N004_1_M10_1_s 0.01
R_VDD_M10_1_b VDD VDD_M10_1_b 0.01
M10_1 VDD_M10_1_d A_1_M10_1_g N004_1_M10_1_s VDD_M10_1_b pmos l=1u w=8u
R_N004_1_M11_1_d N004_1 N004_1_M11_1_d 0.01
R_B_1_M11_1_g B_1 B_1_M11_1_g 0.01
R_N006_1_M11_1_s N006_1 N006_1_M11_1_s 0.01
R_VDD_M11_1_b VDD VDD_M11_1_b 0.01
M11_1 N004_1_M11_1_d B_1_M11_1_g N006_1_M11_1_s VDD_M11_1_b pmos l=1u w=8u
R_N006_1_M12_1_d N006_1 N006_1_M12_1_d 0.01
R_C_1_M12_1_g C_1 C_1_M12_1_g 0.01
R_N007_1_M12_1_s N007_1 N007_1_M12_1_s 0.01
R_VDD_M12_1_b VDD VDD_M12_1_b 0.01
M12_1 N006_1_M12_1_d C_1_M12_1_g N007_1_M12_1_s VDD_M12_1_b pmos l=1u w=8u
R_N007_1_M13_1_d N007_1 N007_1_M13_1_d 0.01
R_C_1_M13_1_g C_1 C_1_M13_1_g 0.01
R_N008_1_M13_1_s N008_1 N008_1_M13_1_s 0.01
M13_1 N007_1_M13_1_d C_1_M13_1_g N008_1_M13_1_s 0 nmos l=1u w=8u
R_N008_1_M14_1_d N008_1 N008_1_M14_1_d 0.01
R_B_1_M14_1_g B_1 B_1_M14_1_g 0.01
R_N012_1_M14_1_s N012_1 N012_1_M14_1_s 0.01
M14_1 N008_1_M14_1_d B_1_M14_1_g N012_1_M14_1_s 0 nmos l=1u w=8u
R_N012_1_M15_1_d N012_1 N012_1_M15_1_d 0.01
R_A_1_M15_1_g A_1 A_1_M15_1_g 0.01
M15_1 N012_1_M15_1_d A_1_M15_1_g 0 0 nmos l=1u w=8u
R_N010_1_M16_1_d N010_1 N010_1_M16_1_d 0.01
R_C_1_M16_1_g C_1 C_1_M16_1_g 0.01
M16_1 N010_1_M16_1_d C_1_M16_1_g 0 0 nmos l=1u w=2u
R_N010_1_M17_1_d N010_1 N010_1_M17_1_d 0.01
R_B_1_M17_1_g B_1 B_1_M17_1_g 0.01
M17_1 N010_1_M17_1_d B_1_M17_1_g 0 0 nmos l=1u w=2u
R_N010_1_M18_1_d N010_1 N010_1_M18_1_d 0.01
R_A_1_M18_1_g A_1 A_1_M18_1_g 0.01
M18_1 N010_1_M18_1_d A_1_M18_1_g 0 0 nmos l=1u w=2u
R_N007_1_M19_1_d N007_1 N007_1_M19_1_d 0.01
R_N005_1_M19_1_g N005_1 N005_1_M19_1_g 0.01
R_N010_1_M19_1_s N010_1 N010_1_M19_1_s 0.01
M19_1 N007_1_M19_1_d N005_1_M19_1_g N010_1_M19_1_s 0 nmos l=1u w=2u
R_N009_1_M20_1_d N009_1 N009_1_M20_1_d 0.01
R_B_1_M20_1_g B_1 B_1_M20_1_g 0.01
M20_1 N009_1_M20_1_d B_1_M20_1_g 0 0 nmos l=1u w=2u
R_N009_1_M21_1_d N009_1 N009_1_M21_1_d 0.01
R_A_1_M21_1_g A_1 A_1_M21_1_g 0.01
M21_1 N009_1_M21_1_d A_1_M21_1_g 0 0 nmos l=1u w=2u
R_N011_1_M22_1_d N011_1 N011_1_M22_1_d 0.01
R_A_1_M22_1_g A_1 A_1_M22_1_g 0.01
M22_1 N011_1_M22_1_d A_1_M22_1_g 0 0 nmos l=1u w=2u
R_N005_1_M23_1_d N005_1 N005_1_M23_1_d 0.01
R_B_1_M23_1_g B_1 B_1_M23_1_g 0.01
R_N011_1_M23_1_s N011_1 N011_1_M23_1_s 0.01
M23_1 N005_1_M23_1_d B_1_M23_1_g N011_1_M23_1_s 0 nmos l=1u w=2u
R_N005_1_M24_1_d N005_1 N005_1_M24_1_d 0.01
R_C_1_M24_1_g C_1 C_1_M24_1_g 0.01
R_N009_1_M24_1_s N009_1 N009_1_M24_1_s 0.01
M24_1 N005_1_M24_1_d C_1_M24_1_g N009_1_M24_1_s 0 nmos l=1u w=2u
R_C_2_M25_1_d C_2 C_2_M25_1_d 0.01
R_N005_1_M25_1_g N005_1 N005_1_M25_1_g 0.01
M25_1 C_2_M25_1_d N005_1_M25_1_g 0 0 nmos l=1u w=1u
R_N002_1_M26_1_d N002_1 N002_1_M26_1_d 0.01
R_N005_1_M26_1_g N005_1 N005_1_M26_1_g 0.01
R_N007_1_M26_1_s N007_1 N007_1_M26_1_s 0.01
R_VDD_M26_1_b VDD VDD_M26_1_b 0.01
M26_1 N002_1_M26_1_d N005_1_M26_1_g N007_1_M26_1_s VDD_M26_1_b pmos l=1u w=4u
R_VDD_M27_1_d VDD VDD_M27_1_d 0.01
R_N007_1_M27_1_g N007_1 N007_1_M27_1_g 0.01
R_S_1_M27_1_s S_1 S_1_M27_1_s 0.01
R_VDD_M27_1_b VDD VDD_M27_1_b 0.01
M27_1 VDD_M27_1_d N007_1_M27_1_g S_1_M27_1_s VDD_M27_1_b pmos l=1u w=2u
R_S_1_M28_1_d S_1 S_1_M28_1_d 0.01
R_N007_1_M28_1_g N007_1 N007_1_M28_1_g 0.01
M28_1 S_1_M28_1_d N007_1_M28_1_g 0 0 nmos l=1u w=1u
C_S_1 S_1 0 1f
* --- Bit 2 ---
R_VDD_M1_2_d VDD VDD_M1_2_d 0.01
R_A_2_M1_2_g A_2 A_2_M1_2_g 0.01
R_N003_2_M1_2_s N003_2 N003_2_M1_2_s 0.01
R_VDD_M1_2_b VDD VDD_M1_2_b 0.01
M1_2 VDD_M1_2_d A_2_M1_2_g N003_2_M1_2_s VDD_M1_2_b pmos l=1u w=4u
R_N003_2_M2_2_d N003_2 N003_2_M2_2_d 0.01
R_B_2_M2_2_g B_2 B_2_M2_2_g 0.01
R_N005_2_M2_2_s N005_2 N005_2_M2_2_s 0.01
R_VDD_M2_2_b VDD VDD_M2_2_b 0.01
M2_2 N003_2_M2_2_d B_2_M2_2_g N005_2_M2_2_s VDD_M2_2_b pmos l=1u w=4u
R_VDD_M3_2_d VDD VDD_M3_2_d 0.01
R_A_2_M3_2_g A_2 A_2_M3_2_g 0.01
R_N001_2_M3_2_s N001_2 N001_2_M3_2_s 0.01
R_VDD_M3_2_b VDD VDD_M3_2_b 0.01
M3_2 VDD_M3_2_d A_2_M3_2_g N001_2_M3_2_s VDD_M3_2_b pmos l=1u w=4u
R_N001_2_M4_2_d N001_2 N001_2_M4_2_d 0.01
R_C_2_M4_2_g C_2 C_2_M4_2_g 0.01
R_N005_2_M4_2_s N005_2 N005_2_M4_2_s 0.01
R_VDD_M4_2_b VDD VDD_M4_2_b 0.01
M4_2 N001_2_M4_2_d C_2_M4_2_g N005_2_M4_2_s VDD_M4_2_b pmos l=1u w=4u
R_VDD_M5_2_d VDD VDD_M5_2_d 0.01
R_B_2_M5_2_g B_2 B_2_M5_2_g 0.01
R_N001_2_M5_2_s N001_2 N001_2_M5_2_s 0.01
R_VDD_M5_2_b VDD VDD_M5_2_b 0.01
M5_2 VDD_M5_2_d B_2_M5_2_g N001_2_M5_2_s VDD_M5_2_b pmos l=1u w=4u
R_VDD_M6_2_d VDD VDD_M6_2_d 0.01
R_N005_2_M6_2_g N005_2 N005_2_M6_2_g 0.01
R_C_3_M6_2_s C_3 C_3_M6_2_s 0.01
R_VDD_M6_2_b VDD VDD_M6_2_b 0.01
M6_2 VDD_M6_2_d N005_2_M6_2_g C_3_M6_2_s VDD_M6_2_b pmos l=1u w=2u
R_VDD_M7_2_d VDD VDD_M7_2_d 0.01
R_A_2_M7_2_g A_2 A_2_M7_2_g 0.01
R_N002_2_M7_2_s N002_2 N002_2_M7_2_s 0.01
R_VDD_M7_2_b VDD VDD_M7_2_b 0.01
M7_2 VDD_M7_2_d A_2_M7_2_g N002_2_M7_2_s VDD_M7_2_b pmos l=1u w=4u
R_VDD_M8_2_d VDD VDD_M8_2_d 0.01
R_B_2_M8_2_g B_2 B_2_M8_2_g 0.01
R_N002_2_M8_2_s N002_2 N002_2_M8_2_s 0.01
R_VDD_M8_2_b VDD VDD_M8_2_b 0.01
M8_2 VDD_M8_2_d B_2_M8_2_g N002_2_M8_2_s VDD_M8_2_b pmos l=1u w=4u
R_VDD_M9_2_d VDD VDD_M9_2_d 0.01
R_C_2_M9_2_g C_2 C_2_M9_2_g 0.01
R_N002_2_M9_2_s N002_2 N002_2_M9_2_s 0.01
R_VDD_M9_2_b VDD VDD_M9_2_b 0.01
M9_2 VDD_M9_2_d C_2_M9_2_g N002_2_M9_2_s VDD_M9_2_b pmos l=1u w=4u
R_VDD_M10_2_d VDD VDD_M10_2_d 0.01
R_A_2_M10_2_g A_2 A_2_M10_2_g 0.01
R_N004_2_M10_2_s N004_2 N004_2_M10_2_s 0.01
R_VDD_M10_2_b VDD VDD_M10_2_b 0.01
M10_2 VDD_M10_2_d A_2_M10_2_g N004_2_M10_2_s VDD_M10_2_b pmos l=1u w=8u
R_N004_2_M11_2_d N004_2 N004_2_M11_2_d 0.01
R_B_2_M11_2_g B_2 B_2_M11_2_g 0.01
R_N006_2_M11_2_s N006_2 N006_2_M11_2_s 0.01
R_VDD_M11_2_b VDD VDD_M11_2_b 0.01
M11_2 N004_2_M11_2_d B_2_M11_2_g N006_2_M11_2_s VDD_M11_2_b pmos l=1u w=8u
R_N006_2_M12_2_d N006_2 N006_2_M12_2_d 0.01
R_C_2_M12_2_g C_2 C_2_M12_2_g 0.01
R_N007_2_M12_2_s N007_2 N007_2_M12_2_s 0.01
R_VDD_M12_2_b VDD VDD_M12_2_b 0.01
M12_2 N006_2_M12_2_d C_2_M12_2_g N007_2_M12_2_s VDD_M12_2_b pmos l=1u w=8u
R_N007_2_M13_2_d N007_2 N007_2_M13_2_d 0.01
R_C_2_M13_2_g C_2 C_2_M13_2_g 0.01
R_N008_2_M13_2_s N008_2 N008_2_M13_2_s 0.01
M13_2 N007_2_M13_2_d C_2_M13_2_g N008_2_M13_2_s 0 nmos l=1u w=8u
R_N008_2_M14_2_d N008_2 N008_2_M14_2_d 0.01
R_B_2_M14_2_g B_2 B_2_M14_2_g 0.01
R_N012_2_M14_2_s N012_2 N012_2_M14_2_s 0.01
M14_2 N008_2_M14_2_d B_2_M14_2_g N012_2_M14_2_s 0 nmos l=1u w=8u
R_N012_2_M15_2_d N012_2 N012_2_M15_2_d 0.01
R_A_2_M15_2_g A_2 A_2_M15_2_g 0.01
M15_2 N012_2_M15_2_d A_2_M15_2_g 0 0 nmos l=1u w=8u
R_N010_2_M16_2_d N010_2 N010_2_M16_2_d 0.01
R_C_2_M16_2_g C_2 C_2_M16_2_g 0.01
M16_2 N010_2_M16_2_d C_2_M16_2_g 0 0 nmos l=1u w=2u
R_N010_2_M17_2_d N010_2 N010_2_M17_2_d 0.01
R_B_2_M17_2_g B_2 B_2_M17_2_g 0.01
M17_2 N010_2_M17_2_d B_2_M17_2_g 0 0 nmos l=1u w=2u
R_N010_2_M18_2_d N010_2 N010_2_M18_2_d 0.01
R_A_2_M18_2_g A_2 A_2_M18_2_g 0.01
M18_2 N010_2_M18_2_d A_2_M18_2_g 0 0 nmos l=1u w=2u
R_N007_2_M19_2_d N007_2 N007_2_M19_2_d 0.01
R_N005_2_M19_2_g N005_2 N005_2_M19_2_g 0.01
R_N010_2_M19_2_s N010_2 N010_2_M19_2_s 0.01
M19_2 N007_2_M19_2_d N005_2_M19_2_g N010_2_M19_2_s 0 nmos l=1u w=2u
R_N009_2_M20_2_d N009_2 N009_2_M20_2_d 0.01
R_B_2_M20_2_g B_2 B_2_M20_2_g 0.01
M20_2 N009_2_M20_2_d B_2_M20_2_g 0 0 nmos l=1u w=2u
R_N009_2_M21_2_d N009_2 N009_2_M21_2_d 0.01
R_A_2_M21_2_g A_2 A_2_M21_2_g 0.01
M21_2 N009_2_M21_2_d A_2_M21_2_g 0 0 nmos l=1u w=2u
R_N011_2_M22_2_d N011_2 N011_2_M22_2_d 0.01
R_A_2_M22_2_g A_2 A_2_M22_2_g 0.01
M22_2 N011_2_M22_2_d A_2_M22_2_g 0 0 nmos l=1u w=2u
R_N005_2_M23_2_d N005_2 N005_2_M23_2_d 0.01
R_B_2_M23_2_g B_2 B_2_M23_2_g 0.01
R_N011_2_M23_2_s N011_2 N011_2_M23_2_s 0.01
M23_2 N005_2_M23_2_d B_2_M23_2_g N011_2_M23_2_s 0 nmos l=1u w=2u
R_N005_2_M24_2_d N005_2 N005_2_M24_2_d 0.01
R_C_2_M24_2_g C_2 C_2_M24_2_g 0.01
R_N009_2_M24_2_s N009_2 N009_2_M24_2_s 0.01
M24_2 N005_2_M24_2_d C_2_M24_2_g N009_2_M24_2_s 0 nmos l=1u w=2u
R_C_3_M25_2_d C_3 C_3_M25_2_d 0.01
R_N005_2_M25_2_g N005_2 N005_2_M25_2_g 0.01
M25_2 C_3_M25_2_d N005_2_M25_2_g 0 0 nmos l=1u w=1u
R_N002_2_M26_2_d N002_2 N002_2_M26_2_d 0.01
R_N005_2_M26_2_g N005_2 N005_2_M26_2_g 0.01
R_N007_2_M26_2_s N007_2 N007_2_M26_2_s 0.01
R_VDD_M26_2_b VDD VDD_M26_2_b 0.01
M26_2 N002_2_M26_2_d N005_2_M26_2_g N007_2_M26_2_s VDD_M26_2_b pmos l=1u w=4u
R_VDD_M27_2_d VDD VDD_M27_2_d 0.01
R_N007_2_M27_2_g N007_2 N007_2_M27_2_g 0.01
R_S_2_M27_2_s S_2 S_2_M27_2_s 0.01
R_VDD_M27_2_b VDD VDD_M27_2_b 0.01
M27_2 VDD_M27_2_d N007_2_M27_2_g S_2_M27_2_s VDD_M27_2_b pmos l=1u w=2u
R_S_2_M28_2_d S_2 S_2_M28_2_d 0.01
R_N007_2_M28_2_g N007_2 N007_2_M28_2_g 0.01
M28_2 S_2_M28_2_d N007_2_M28_2_g 0 0 nmos l=1u w=1u
C_S_2 S_2 0 1f
* --- Bit 3 ---
R_VDD_M1_3_d VDD VDD_M1_3_d 0.01
R_A_3_M1_3_g A_3 A_3_M1_3_g 0.01
R_N003_3_M1_3_s N003_3 N003_3_M1_3_s 0.01
R_VDD_M1_3_b VDD VDD_M1_3_b 0.01
M1_3 VDD_M1_3_d A_3_M1_3_g N003_3_M1_3_s VDD_M1_3_b pmos l=1u w=4u
R_N003_3_M2_3_d N003_3 N003_3_M2_3_d 0.01
R_B_3_M2_3_g B_3 B_3_M2_3_g 0.01
R_N005_3_M2_3_s N005_3 N005_3_M2_3_s 0.01
R_VDD_M2_3_b VDD VDD_M2_3_b 0.01
M2_3 N003_3_M2_3_d B_3_M2_3_g N005_3_M2_3_s VDD_M2_3_b pmos l=1u w=4u
R_VDD_M3_3_d VDD VDD_M3_3_d 0.01
R_A_3_M3_3_g A_3 A_3_M3_3_g 0.01
R_N001_3_M3_3_s N001_3 N001_3_M3_3_s 0.01
R_VDD_M3_3_b VDD VDD_M3_3_b 0.01
M3_3 VDD_M3_3_d A_3_M3_3_g N001_3_M3_3_s VDD_M3_3_b pmos l=1u w=4u
R_N001_3_M4_3_d N001_3 N001_3_M4_3_d 0.01
R_C_3_M4_3_g C_3 C_3_M4_3_g 0.01
R_N005_3_M4_3_s N005_3 N005_3_M4_3_s 0.01
R_VDD_M4_3_b VDD VDD_M4_3_b 0.01
M4_3 N001_3_M4_3_d C_3_M4_3_g N005_3_M4_3_s VDD_M4_3_b pmos l=1u w=4u
R_VDD_M5_3_d VDD VDD_M5_3_d 0.01
R_B_3_M5_3_g B_3 B_3_M5_3_g 0.01
R_N001_3_M5_3_s N001_3 N001_3_M5_3_s 0.01
R_VDD_M5_3_b VDD VDD_M5_3_b 0.01
M5_3 VDD_M5_3_d B_3_M5_3_g N001_3_M5_3_s VDD_M5_3_b pmos l=1u w=4u
R_VDD_M6_3_d VDD VDD_M6_3_d 0.01
R_N005_3_M6_3_g N005_3 N005_3_M6_3_g 0.01
R_C_4_M6_3_s C_4 C_4_M6_3_s 0.01
R_VDD_M6_3_b VDD VDD_M6_3_b 0.01
M6_3 VDD_M6_3_d N005_3_M6_3_g C_4_M6_3_s VDD_M6_3_b pmos l=1u w=2u
R_VDD_M7_3_d VDD VDD_M7_3_d 0.01
R_A_3_M7_3_g A_3 A_3_M7_3_g 0.01
R_N002_3_M7_3_s N002_3 N002_3_M7_3_s 0.01
R_VDD_M7_3_b VDD VDD_M7_3_b 0.01
M7_3 VDD_M7_3_d A_3_M7_3_g N002_3_M7_3_s VDD_M7_3_b pmos l=1u w=4u
R_VDD_M8_3_d VDD VDD_M8_3_d 0.01
R_B_3_M8_3_g B_3 B_3_M8_3_g 0.01
R_N002_3_M8_3_s N002_3 N002_3_M8_3_s 0.01
R_VDD_M8_3_b VDD VDD_M8_3_b 0.01
M8_3 VDD_M8_3_d B_3_M8_3_g N002_3_M8_3_s VDD_M8_3_b pmos l=1u w=4u
R_VDD_M9_3_d VDD VDD_M9_3_d 0.01
R_C_3_M9_3_g C_3 C_3_M9_3_g 0.01
R_N002_3_M9_3_s N002_3 N002_3_M9_3_s 0.01
R_VDD_M9_3_b VDD VDD_M9_3_b 0.01
M9_3 VDD_M9_3_d C_3_M9_3_g N002_3_M9_3_s VDD_M9_3_b pmos l=1u w=4u
R_VDD_M10_3_d VDD VDD_M10_3_d 0.01
R_A_3_M10_3_g A_3 A_3_M10_3_g 0.01
R_N004_3_M10_3_s N004_3 N004_3_M10_3_s 0.01
R_VDD_M10_3_b VDD VDD_M10_3_b 0.01
M10_3 VDD_M10_3_d A_3_M10_3_g N004_3_M10_3_s VDD_M10_3_b pmos l=1u w=8u
R_N004_3_M11_3_d N004_3 N004_3_M11_3_d 0.01
R_B_3_M11_3_g B_3 B_3_M11_3_g 0.01
R_N006_3_M11_3_s N006_3 N006_3_M11_3_s 0.01
R_VDD_M11_3_b VDD VDD_M11_3_b 0.01
M11_3 N004_3_M11_3_d B_3_M11_3_g N006_3_M11_3_s VDD_M11_3_b pmos l=1u w=8u
R_N006_3_M12_3_d N006_3 N006_3_M12_3_d 0.01
R_C_3_M12_3_g C_3 C_3_M12_3_g 0.01
R_N007_3_M12_3_s N007_3 N007_3_M12_3_s 0.01
R_VDD_M12_3_b VDD VDD_M12_3_b 0.01
M12_3 N006_3_M12_3_d C_3_M12_3_g N007_3_M12_3_s VDD_M12_3_b pmos l=1u w=8u
R_N007_3_M13_3_d N007_3 N007_3_M13_3_d 0.01
R_C_3_M13_3_g C_3 C_3_M13_3_g 0.01
R_N008_3_M13_3_s N008_3 N008_3_M13_3_s 0.01
M13_3 N007_3_M13_3_d C_3_M13_3_g N008_3_M13_3_s 0 nmos l=1u w=8u
R_N008_3_M14_3_d N008_3 N008_3_M14_3_d 0.01
R_B_3_M14_3_g B_3 B_3_M14_3_g 0.01
R_N012_3_M14_3_s N012_3 N012_3_M14_3_s 0.01
M14_3 N008_3_M14_3_d B_3_M14_3_g N012_3_M14_3_s 0 nmos l=1u w=8u
R_N012_3_M15_3_d N012_3 N012_3_M15_3_d 0.01
R_A_3_M15_3_g A_3 A_3_M15_3_g 0.01
M15_3 N012_3_M15_3_d A_3_M15_3_g 0 0 nmos l=1u w=8u
R_N010_3_M16_3_d N010_3 N010_3_M16_3_d 0.01
R_C_3_M16_3_g C_3 C_3_M16_3_g 0.01
M16_3 N010_3_M16_3_d C_3_M16_3_g 0 0 nmos l=1u w=2u
R_N010_3_M17_3_d N010_3 N010_3_M17_3_d 0.01
R_B_3_M17_3_g B_3 B_3_M17_3_g 0.01
M17_3 N010_3_M17_3_d B_3_M17_3_g 0 0 nmos l=1u w=2u
R_N010_3_M18_3_d N010_3 N010_3_M18_3_d 0.01
R_A_3_M18_3_g A_3 A_3_M18_3_g 0.01
M18_3 N010_3_M18_3_d A_3_M18_3_g 0 0 nmos l=1u w=2u
R_N007_3_M19_3_d N007_3 N007_3_M19_3_d 0.01
R_N005_3_M19_3_g N005_3 N005_3_M19_3_g 0.01
R_N010_3_M19_3_s N010_3 N010_3_M19_3_s 0.01
M19_3 N007_3_M19_3_d N005_3_M19_3_g N010_3_M19_3_s 0 nmos l=1u w=2u
R_N009_3_M20_3_d N009_3 N009_3_M20_3_d 0.01
R_B_3_M20_3_g B_3 B_3_M20_3_g 0.01
M20_3 N009_3_M20_3_d B_3_M20_3_g 0 0 nmos l=1u w=2u
R_N009_3_M21_3_d N009_3 N009_3_M21_3_d 0.01
R_A_3_M21_3_g A_3 A_3_M21_3_g 0.01
M21_3 N009_3_M21_3_d A_3_M21_3_g 0 0 nmos l=1u w=2u
R_N011_3_M22_3_d N011_3 N011_3_M22_3_d 0.01
R_A_3_M22_3_g A_3 A_3_M22_3_g 0.01
M22_3 N011_3_M22_3_d A_3_M22_3_g 0 0 nmos l=1u w=2u
R_N005_3_M23_3_d N005_3 N005_3_M23_3_d 0.01
R_B_3_M23_3_g B_3 B_3_M23_3_g 0.01
R_N011_3_M23_3_s N011_3 N011_3_M23_3_s 0.01
M23_3 N005_3_M23_3_d B_3_M23_3_g N011_3_M23_3_s 0 nmos l=1u w=2u
R_N005_3_M24_3_d N005_3 N005_3_M24_3_d 0.01
R_C_3_M24_3_g C_3 C_3_M24_3_g 0.01
R_N009_3_M24_3_s N009_3 N009_3_M24_3_s 0.01
M24_3 N005_3_M24_3_d C_3_M24_3_g N009_3_M24_3_s 0 nmos l=1u w=2u
R_C_4_M25_3_d C_4 C_4_M25_3_d 0.01
R_N005_3_M25_3_g N005_3 N005_3_M25_3_g 0.01
M25_3 C_4_M25_3_d N005_3_M25_3_g 0 0 nmos l=1u w=1u
R_N002_3_M26_3_d N002_3 N002_3_M26_3_d 0.01
R_N005_3_M26_3_g N005_3 N005_3_M26_3_g 0.01
R_N007_3_M26_3_s N007_3 N007_3_M26_3_s 0.01
R_VDD_M26_3_b VDD VDD_M26_3_b 0.01
M26_3 N002_3_M26_3_d N005_3_M26_3_g N007_3_M26_3_s VDD_M26_3_b pmos l=1u w=4u
R_VDD_M27_3_d VDD VDD_M27_3_d 0.01
R_N007_3_M27_3_g N007_3 N007_3_M27_3_g 0.01
R_S_3_M27_3_s S_3 S_3_M27_3_s 0.01
R_VDD_M27_3_b VDD VDD_M27_3_b 0.01
M27_3 VDD_M27_3_d N007_3_M27_3_g S_3_M27_3_s VDD_M27_3_b pmos l=1u w=2u
R_S_3_M28_3_d S_3 S_3_M28_3_d 0.01
R_N007_3_M28_3_g N007_3 N007_3_M28_3_g 0.01
M28_3 S_3_M28_3_d N007_3_M28_3_g 0 0 nmos l=1u w=1u
C_S_3 S_3 0 1f
* --- Bit 4 ---
R_VDD_M1_4_d VDD VDD_M1_4_d 0.01
R_A_4_M1_4_g A_4 A_4_M1_4_g 0.01
R_N003_4_M1_4_s N003_4 N003_4_M1_4_s 0.01
R_VDD_M1_4_b VDD VDD_M1_4_b 0.01
M1_4 VDD_M1_4_d A_4_M1_4_g N003_4_M1_4_s VDD_M1_4_b pmos l=1u w=4u
R_N003_4_M2_4_d N003_4 N003_4_M2_4_d 0.01
R_B_4_M2_4_g B_4 B_4_M2_4_g 0.01
R_N005_4_M2_4_s N005_4 N005_4_M2_4_s 0.01
R_VDD_M2_4_b VDD VDD_M2_4_b 0.01
M2_4 N003_4_M2_4_d B_4_M2_4_g N005_4_M2_4_s VDD_M2_4_b pmos l=1u w=4u
R_VDD_M3_4_d VDD VDD_M3_4_d 0.01
R_A_4_M3_4_g A_4 A_4_M3_4_g 0.01
R_N001_4_M3_4_s N001_4 N001_4_M3_4_s 0.01
R_VDD_M3_4_b VDD VDD_M3_4_b 0.01
M3_4 VDD_M3_4_d A_4_M3_4_g N001_4_M3_4_s VDD_M3_4_b pmos l=1u w=4u
R_N001_4_M4_4_d N001_4 N001_4_M4_4_d 0.01
R_C_4_M4_4_g C_4 C_4_M4_4_g 0.01
R_N005_4_M4_4_s N005_4 N005_4_M4_4_s 0.01
R_VDD_M4_4_b VDD VDD_M4_4_b 0.01
M4_4 N001_4_M4_4_d C_4_M4_4_g N005_4_M4_4_s VDD_M4_4_b pmos l=1u w=4u
R_VDD_M5_4_d VDD VDD_M5_4_d 0.01
R_B_4_M5_4_g B_4 B_4_M5_4_g 0.01
R_N001_4_M5_4_s N001_4 N001_4_M5_4_s 0.01
R_VDD_M5_4_b VDD VDD_M5_4_b 0.01
M5_4 VDD_M5_4_d B_4_M5_4_g N001_4_M5_4_s VDD_M5_4_b pmos l=1u w=4u
R_VDD_M6_4_d VDD VDD_M6_4_d 0.01
R_N005_4_M6_4_g N005_4 N005_4_M6_4_g 0.01
R_C_5_M6_4_s C_5 C_5_M6_4_s 0.01
R_VDD_M6_4_b VDD VDD_M6_4_b 0.01
M6_4 VDD_M6_4_d N005_4_M6_4_g C_5_M6_4_s VDD_M6_4_b pmos l=1u w=2u
R_VDD_M7_4_d VDD VDD_M7_4_d 0.01
R_A_4_M7_4_g A_4 A_4_M7_4_g 0.01
R_N002_4_M7_4_s N002_4 N002_4_M7_4_s 0.01
R_VDD_M7_4_b VDD VDD_M7_4_b 0.01
M7_4 VDD_M7_4_d A_4_M7_4_g N002_4_M7_4_s VDD_M7_4_b pmos l=1u w=4u
R_VDD_M8_4_d VDD VDD_M8_4_d 0.01
R_B_4_M8_4_g B_4 B_4_M8_4_g 0.01
R_N002_4_M8_4_s N002_4 N002_4_M8_4_s 0.01
R_VDD_M8_4_b VDD VDD_M8_4_b 0.01
M8_4 VDD_M8_4_d B_4_M8_4_g N002_4_M8_4_s VDD_M8_4_b pmos l=1u w=4u
R_VDD_M9_4_d VDD VDD_M9_4_d 0.01
R_C_4_M9_4_g C_4 C_4_M9_4_g 0.01
R_N002_4_M9_4_s N002_4 N002_4_M9_4_s 0.01
R_VDD_M9_4_b VDD VDD_M9_4_b 0.01
M9_4 VDD_M9_4_d C_4_M9_4_g N002_4_M9_4_s VDD_M9_4_b pmos l=1u w=4u
R_VDD_M10_4_d VDD VDD_M10_4_d 0.01
R_A_4_M10_4_g A_4 A_4_M10_4_g 0.01
R_N004_4_M10_4_s N004_4 N004_4_M10_4_s 0.01
R_VDD_M10_4_b VDD VDD_M10_4_b 0.01
M10_4 VDD_M10_4_d A_4_M10_4_g N004_4_M10_4_s VDD_M10_4_b pmos l=1u w=8u
R_N004_4_M11_4_d N004_4 N004_4_M11_4_d 0.01
R_B_4_M11_4_g B_4 B_4_M11_4_g 0.01
R_N006_4_M11_4_s N006_4 N006_4_M11_4_s 0.01
R_VDD_M11_4_b VDD VDD_M11_4_b 0.01
M11_4 N004_4_M11_4_d B_4_M11_4_g N006_4_M11_4_s VDD_M11_4_b pmos l=1u w=8u
R_N006_4_M12_4_d N006_4 N006_4_M12_4_d 0.01
R_C_4_M12_4_g C_4 C_4_M12_4_g 0.01
R_N007_4_M12_4_s N007_4 N007_4_M12_4_s 0.01
R_VDD_M12_4_b VDD VDD_M12_4_b 0.01
M12_4 N006_4_M12_4_d C_4_M12_4_g N007_4_M12_4_s VDD_M12_4_b pmos l=1u w=8u
R_N007_4_M13_4_d N007_4 N007_4_M13_4_d 0.01
R_C_4_M13_4_g C_4 C_4_M13_4_g 0.01
R_N008_4_M13_4_s N008_4 N008_4_M13_4_s 0.01
M13_4 N007_4_M13_4_d C_4_M13_4_g N008_4_M13_4_s 0 nmos l=1u w=8u
R_N008_4_M14_4_d N008_4 N008_4_M14_4_d 0.01
R_B_4_M14_4_g B_4 B_4_M14_4_g 0.01
R_N012_4_M14_4_s N012_4 N012_4_M14_4_s 0.01
M14_4 N008_4_M14_4_d B_4_M14_4_g N012_4_M14_4_s 0 nmos l=1u w=8u
R_N012_4_M15_4_d N012_4 N012_4_M15_4_d 0.01
R_A_4_M15_4_g A_4 A_4_M15_4_g 0.01
M15_4 N012_4_M15_4_d A_4_M15_4_g 0 0 nmos l=1u w=8u
R_N010_4_M16_4_d N010_4 N010_4_M16_4_d 0.01
R_C_4_M16_4_g C_4 C_4_M16_4_g 0.01
M16_4 N010_4_M16_4_d C_4_M16_4_g 0 0 nmos l=1u w=2u
R_N010_4_M17_4_d N010_4 N010_4_M17_4_d 0.01
R_B_4_M17_4_g B_4 B_4_M17_4_g 0.01
M17_4 N010_4_M17_4_d B_4_M17_4_g 0 0 nmos l=1u w=2u
R_N010_4_M18_4_d N010_4 N010_4_M18_4_d 0.01
R_A_4_M18_4_g A_4 A_4_M18_4_g 0.01
M18_4 N010_4_M18_4_d A_4_M18_4_g 0 0 nmos l=1u w=2u
R_N007_4_M19_4_d N007_4 N007_4_M19_4_d 0.01
R_N005_4_M19_4_g N005_4 N005_4_M19_4_g 0.01
R_N010_4_M19_4_s N010_4 N010_4_M19_4_s 0.01
M19_4 N007_4_M19_4_d N005_4_M19_4_g N010_4_M19_4_s 0 nmos l=1u w=2u
R_N009_4_M20_4_d N009_4 N009_4_M20_4_d 0.01
R_B_4_M20_4_g B_4 B_4_M20_4_g 0.01
M20_4 N009_4_M20_4_d B_4_M20_4_g 0 0 nmos l=1u w=2u
R_N009_4_M21_4_d N009_4 N009_4_M21_4_d 0.01
R_A_4_M21_4_g A_4 A_4_M21_4_g 0.01
M21_4 N009_4_M21_4_d A_4_M21_4_g 0 0 nmos l=1u w=2u
R_N011_4_M22_4_d N011_4 N011_4_M22_4_d 0.01
R_A_4_M22_4_g A_4 A_4_M22_4_g 0.01
M22_4 N011_4_M22_4_d A_4_M22_4_g 0 0 nmos l=1u w=2u
R_N005_4_M23_4_d N005_4 N005_4_M23_4_d 0.01
R_B_4_M23_4_g B_4 B_4_M23_4_g 0.01
R_N011_4_M23_4_s N011_4 N011_4_M23_4_s 0.01
M23_4 N005_4_M23_4_d B_4_M23_4_g N011_4_M23_4_s 0 nmos l=1u w=2u
R_N005_4_M24_4_d N005_4 N005_4_M24_4_d 0.01
R_C_4_M24_4_g C_4 C_4_M24_4_g 0.01
R_N009_4_M24_4_s N009_4 N009_4_M24_4_s 0.01
M24_4 N005_4_M24_4_d C_4_M24_4_g N009_4_M24_4_s 0 nmos l=1u w=2u
R_C_5_M25_4_d C_5 C_5_M25_4_d 0.01
R_N005_4_M25_4_g N005_4 N005_4_M25_4_g 0.01
M25_4 C_5_M25_4_d N005_4_M25_4_g 0 0 nmos l=1u w=1u
R_N002_4_M26_4_d N002_4 N002_4_M26_4_d 0.01
R_N005_4_M26_4_g N005_4 N005_4_M26_4_g 0.01
R_N007_4_M26_4_s N007_4 N007_4_M26_4_s 0.01
R_VDD_M26_4_b VDD VDD_M26_4_b 0.01
M26_4 N002_4_M26_4_d N005_4_M26_4_g N007_4_M26_4_s VDD_M26_4_b pmos l=1u w=4u
R_VDD_M27_4_d VDD VDD_M27_4_d 0.01
R_N007_4_M27_4_g N007_4 N007_4_M27_4_g 0.01
R_S_4_M27_4_s S_4 S_4_M27_4_s 0.01
R_VDD_M27_4_b VDD VDD_M27_4_b 0.01
M27_4 VDD_M27_4_d N007_4_M27_4_g S_4_M27_4_s VDD_M27_4_b pmos l=1u w=2u
R_S_4_M28_4_d S_4 S_4_M28_4_d 0.01
R_N007_4_M28_4_g N007_4 N007_4_M28_4_g 0.01
M28_4 S_4_M28_4_d N007_4_M28_4_g 0 0 nmos l=1u w=1u
C_S_4 S_4 0 1f
* --- Bit 5 ---
R_VDD_M1_5_d VDD VDD_M1_5_d 0.01
R_A_5_M1_5_g A_5 A_5_M1_5_g 0.01
R_N003_5_M1_5_s N003_5 N003_5_M1_5_s 0.01
R_VDD_M1_5_b VDD VDD_M1_5_b 0.01
M1_5 VDD_M1_5_d A_5_M1_5_g N003_5_M1_5_s VDD_M1_5_b pmos l=1u w=4u
R_N003_5_M2_5_d N003_5 N003_5_M2_5_d 0.01
R_B_5_M2_5_g B_5 B_5_M2_5_g 0.01
R_N005_5_M2_5_s N005_5 N005_5_M2_5_s 0.01
R_VDD_M2_5_b VDD VDD_M2_5_b 0.01
M2_5 N003_5_M2_5_d B_5_M2_5_g N005_5_M2_5_s VDD_M2_5_b pmos l=1u w=4u
R_VDD_M3_5_d VDD VDD_M3_5_d 0.01
R_A_5_M3_5_g A_5 A_5_M3_5_g 0.01
R_N001_5_M3_5_s N001_5 N001_5_M3_5_s 0.01
R_VDD_M3_5_b VDD VDD_M3_5_b 0.01
M3_5 VDD_M3_5_d A_5_M3_5_g N001_5_M3_5_s VDD_M3_5_b pmos l=1u w=4u
R_N001_5_M4_5_d N001_5 N001_5_M4_5_d 0.01
R_C_5_M4_5_g C_5 C_5_M4_5_g 0.01
R_N005_5_M4_5_s N005_5 N005_5_M4_5_s 0.01
R_VDD_M4_5_b VDD VDD_M4_5_b 0.01
M4_5 N001_5_M4_5_d C_5_M4_5_g N005_5_M4_5_s VDD_M4_5_b pmos l=1u w=4u
R_VDD_M5_5_d VDD VDD_M5_5_d 0.01
R_B_5_M5_5_g B_5 B_5_M5_5_g 0.01
R_N001_5_M5_5_s N001_5 N001_5_M5_5_s 0.01
R_VDD_M5_5_b VDD VDD_M5_5_b 0.01
M5_5 VDD_M5_5_d B_5_M5_5_g N001_5_M5_5_s VDD_M5_5_b pmos l=1u w=4u
R_VDD_M6_5_d VDD VDD_M6_5_d 0.01
R_N005_5_M6_5_g N005_5 N005_5_M6_5_g 0.01
R_C_6_M6_5_s C_6 C_6_M6_5_s 0.01
R_VDD_M6_5_b VDD VDD_M6_5_b 0.01
M6_5 VDD_M6_5_d N005_5_M6_5_g C_6_M6_5_s VDD_M6_5_b pmos l=1u w=2u
R_VDD_M7_5_d VDD VDD_M7_5_d 0.01
R_A_5_M7_5_g A_5 A_5_M7_5_g 0.01
R_N002_5_M7_5_s N002_5 N002_5_M7_5_s 0.01
R_VDD_M7_5_b VDD VDD_M7_5_b 0.01
M7_5 VDD_M7_5_d A_5_M7_5_g N002_5_M7_5_s VDD_M7_5_b pmos l=1u w=4u
R_VDD_M8_5_d VDD VDD_M8_5_d 0.01
R_B_5_M8_5_g B_5 B_5_M8_5_g 0.01
R_N002_5_M8_5_s N002_5 N002_5_M8_5_s 0.01
R_VDD_M8_5_b VDD VDD_M8_5_b 0.01
M8_5 VDD_M8_5_d B_5_M8_5_g N002_5_M8_5_s VDD_M8_5_b pmos l=1u w=4u
R_VDD_M9_5_d VDD VDD_M9_5_d 0.01
R_C_5_M9_5_g C_5 C_5_M9_5_g 0.01
R_N002_5_M9_5_s N002_5 N002_5_M9_5_s 0.01
R_VDD_M9_5_b VDD VDD_M9_5_b 0.01
M9_5 VDD_M9_5_d C_5_M9_5_g N002_5_M9_5_s VDD_M9_5_b pmos l=1u w=4u
R_VDD_M10_5_d VDD VDD_M10_5_d 0.01
R_A_5_M10_5_g A_5 A_5_M10_5_g 0.01
R_N004_5_M10_5_s N004_5 N004_5_M10_5_s 0.01
R_VDD_M10_5_b VDD VDD_M10_5_b 0.01
M10_5 VDD_M10_5_d A_5_M10_5_g N004_5_M10_5_s VDD_M10_5_b pmos l=1u w=8u
R_N004_5_M11_5_d N004_5 N004_5_M11_5_d 0.01
R_B_5_M11_5_g B_5 B_5_M11_5_g 0.01
R_N006_5_M11_5_s N006_5 N006_5_M11_5_s 0.01
R_VDD_M11_5_b VDD VDD_M11_5_b 0.01
M11_5 N004_5_M11_5_d B_5_M11_5_g N006_5_M11_5_s VDD_M11_5_b pmos l=1u w=8u
R_N006_5_M12_5_d N006_5 N006_5_M12_5_d 0.01
R_C_5_M12_5_g C_5 C_5_M12_5_g 0.01
R_N007_5_M12_5_s N007_5 N007_5_M12_5_s 0.01
R_VDD_M12_5_b VDD VDD_M12_5_b 0.01
M12_5 N006_5_M12_5_d C_5_M12_5_g N007_5_M12_5_s VDD_M12_5_b pmos l=1u w=8u
R_N007_5_M13_5_d N007_5 N007_5_M13_5_d 0.01
R_C_5_M13_5_g C_5 C_5_M13_5_g 0.01
R_N008_5_M13_5_s N008_5 N008_5_M13_5_s 0.01
M13_5 N007_5_M13_5_d C_5_M13_5_g N008_5_M13_5_s 0 nmos l=1u w=8u
R_N008_5_M14_5_d N008_5 N008_5_M14_5_d 0.01
R_B_5_M14_5_g B_5 B_5_M14_5_g 0.01
R_N012_5_M14_5_s N012_5 N012_5_M14_5_s 0.01
M14_5 N008_5_M14_5_d B_5_M14_5_g N012_5_M14_5_s 0 nmos l=1u w=8u
R_N012_5_M15_5_d N012_5 N012_5_M15_5_d 0.01
R_A_5_M15_5_g A_5 A_5_M15_5_g 0.01
M15_5 N012_5_M15_5_d A_5_M15_5_g 0 0 nmos l=1u w=8u
R_N010_5_M16_5_d N010_5 N010_5_M16_5_d 0.01
R_C_5_M16_5_g C_5 C_5_M16_5_g 0.01
M16_5 N010_5_M16_5_d C_5_M16_5_g 0 0 nmos l=1u w=2u
R_N010_5_M17_5_d N010_5 N010_5_M17_5_d 0.01
R_B_5_M17_5_g B_5 B_5_M17_5_g 0.01
M17_5 N010_5_M17_5_d B_5_M17_5_g 0 0 nmos l=1u w=2u
R_N010_5_M18_5_d N010_5 N010_5_M18_5_d 0.01
R_A_5_M18_5_g A_5 A_5_M18_5_g 0.01
M18_5 N010_5_M18_5_d A_5_M18_5_g 0 0 nmos l=1u w=2u
R_N007_5_M19_5_d N007_5 N007_5_M19_5_d 0.01
R_N005_5_M19_5_g N005_5 N005_5_M19_5_g 0.01
R_N010_5_M19_5_s N010_5 N010_5_M19_5_s 0.01
M19_5 N007_5_M19_5_d N005_5_M19_5_g N010_5_M19_5_s 0 nmos l=1u w=2u
R_N009_5_M20_5_d N009_5 N009_5_M20_5_d 0.01
R_B_5_M20_5_g B_5 B_5_M20_5_g 0.01
M20_5 N009_5_M20_5_d B_5_M20_5_g 0 0 nmos l=1u w=2u
R_N009_5_M21_5_d N009_5 N009_5_M21_5_d 0.01
R_A_5_M21_5_g A_5 A_5_M21_5_g 0.01
M21_5 N009_5_M21_5_d A_5_M21_5_g 0 0 nmos l=1u w=2u
R_N011_5_M22_5_d N011_5 N011_5_M22_5_d 0.01
R_A_5_M22_5_g A_5 A_5_M22_5_g 0.01
M22_5 N011_5_M22_5_d A_5_M22_5_g 0 0 nmos l=1u w=2u
R_N005_5_M23_5_d N005_5 N005_5_M23_5_d 0.01
R_B_5_M23_5_g B_5 B_5_M23_5_g 0.01
R_N011_5_M23_5_s N011_5 N011_5_M23_5_s 0.01
M23_5 N005_5_M23_5_d B_5_M23_5_g N011_5_M23_5_s 0 nmos l=1u w=2u
R_N005_5_M24_5_d N005_5 N005_5_M24_5_d 0.01
R_C_5_M24_5_g C_5 C_5_M24_5_g 0.01
R_N009_5_M24_5_s N009_5 N009_5_M24_5_s 0.01
M24_5 N005_5_M24_5_d C_5_M24_5_g N009_5_M24_5_s 0 nmos l=1u w=2u
R_C_6_M25_5_d C_6 C_6_M25_5_d 0.01
R_N005_5_M25_5_g N005_5 N005_5_M25_5_g 0.01
M25_5 C_6_M25_5_d N005_5_M25_5_g 0 0 nmos l=1u w=1u
R_N002_5_M26_5_d N002_5 N002_5_M26_5_d 0.01
R_N005_5_M26_5_g N005_5 N005_5_M26_5_g 0.01
R_N007_5_M26_5_s N007_5 N007_5_M26_5_s 0.01
R_VDD_M26_5_b VDD VDD_M26_5_b 0.01
M26_5 N002_5_M26_5_d N005_5_M26_5_g N007_5_M26_5_s VDD_M26_5_b pmos l=1u w=4u
R_VDD_M27_5_d VDD VDD_M27_5_d 0.01
R_N007_5_M27_5_g N007_5 N007_5_M27_5_g 0.01
R_S_5_M27_5_s S_5 S_5_M27_5_s 0.01
R_VDD_M27_5_b VDD VDD_M27_5_b 0.01
M27_5 VDD_M27_5_d N007_5_M27_5_g S_5_M27_5_s VDD_M27_5_b pmos l=1u w=2u
R_S_5_M28_5_d S_5 S_5_M28_5_d 0.01
R_N007_5_M28_5_g N007_5 N007_5_M28_5_g 0.01
M28_5 S_5_M28_5_d N007_5_M28_5_g 0 0 nmos l=1u w=1u
C_S_5 S_5 0 1f
* --- Bit 6 ---
R_VDD_M1_6_d VDD VDD_M1_6_d 0.01
R_A_6_M1_6_g A_6 A_6_M1_6_g 0.01
R_N003_6_M1_6_s N003_6 N003_6_M1_6_s 0.01
R_VDD_M1_6_b VDD VDD_M1_6_b 0.01
M1_6 VDD_M1_6_d A_6_M1_6_g N003_6_M1_6_s VDD_M1_6_b pmos l=1u w=4u
R_N003_6_M2_6_d N003_6 N003_6_M2_6_d 0.01
R_B_6_M2_6_g B_6 B_6_M2_6_g 0.01
R_N005_6_M2_6_s N005_6 N005_6_M2_6_s 0.01
R_VDD_M2_6_b VDD VDD_M2_6_b 0.01
M2_6 N003_6_M2_6_d B_6_M2_6_g N005_6_M2_6_s VDD_M2_6_b pmos l=1u w=4u
R_VDD_M3_6_d VDD VDD_M3_6_d 0.01
R_A_6_M3_6_g A_6 A_6_M3_6_g 0.01
R_N001_6_M3_6_s N001_6 N001_6_M3_6_s 0.01
R_VDD_M3_6_b VDD VDD_M3_6_b 0.01
M3_6 VDD_M3_6_d A_6_M3_6_g N001_6_M3_6_s VDD_M3_6_b pmos l=1u w=4u
R_N001_6_M4_6_d N001_6 N001_6_M4_6_d 0.01
R_C_6_M4_6_g C_6 C_6_M4_6_g 0.01
R_N005_6_M4_6_s N005_6 N005_6_M4_6_s 0.01
R_VDD_M4_6_b VDD VDD_M4_6_b 0.01
M4_6 N001_6_M4_6_d C_6_M4_6_g N005_6_M4_6_s VDD_M4_6_b pmos l=1u w=4u
R_VDD_M5_6_d VDD VDD_M5_6_d 0.01
R_B_6_M5_6_g B_6 B_6_M5_6_g 0.01
R_N001_6_M5_6_s N001_6 N001_6_M5_6_s 0.01
R_VDD_M5_6_b VDD VDD_M5_6_b 0.01
M5_6 VDD_M5_6_d B_6_M5_6_g N001_6_M5_6_s VDD_M5_6_b pmos l=1u w=4u
R_VDD_M6_6_d VDD VDD_M6_6_d 0.01
R_N005_6_M6_6_g N005_6 N005_6_M6_6_g 0.01
R_C_7_M6_6_s C_7 C_7_M6_6_s 0.01
R_VDD_M6_6_b VDD VDD_M6_6_b 0.01
M6_6 VDD_M6_6_d N005_6_M6_6_g C_7_M6_6_s VDD_M6_6_b pmos l=1u w=2u
R_VDD_M7_6_d VDD VDD_M7_6_d 0.01
R_A_6_M7_6_g A_6 A_6_M7_6_g 0.01
R_N002_6_M7_6_s N002_6 N002_6_M7_6_s 0.01
R_VDD_M7_6_b VDD VDD_M7_6_b 0.01
M7_6 VDD_M7_6_d A_6_M7_6_g N002_6_M7_6_s VDD_M7_6_b pmos l=1u w=4u
R_VDD_M8_6_d VDD VDD_M8_6_d 0.01
R_B_6_M8_6_g B_6 B_6_M8_6_g 0.01
R_N002_6_M8_6_s N002_6 N002_6_M8_6_s 0.01
R_VDD_M8_6_b VDD VDD_M8_6_b 0.01
M8_6 VDD_M8_6_d B_6_M8_6_g N002_6_M8_6_s VDD_M8_6_b pmos l=1u w=4u
R_VDD_M9_6_d VDD VDD_M9_6_d 0.01
R_C_6_M9_6_g C_6 C_6_M9_6_g 0.01
R_N002_6_M9_6_s N002_6 N002_6_M9_6_s 0.01
R_VDD_M9_6_b VDD VDD_M9_6_b 0.01
M9_6 VDD_M9_6_d C_6_M9_6_g N002_6_M9_6_s VDD_M9_6_b pmos l=1u w=4u
R_VDD_M10_6_d VDD VDD_M10_6_d 0.01
R_A_6_M10_6_g A_6 A_6_M10_6_g 0.01
R_N004_6_M10_6_s N004_6 N004_6_M10_6_s 0.01
R_VDD_M10_6_b VDD VDD_M10_6_b 0.01
M10_6 VDD_M10_6_d A_6_M10_6_g N004_6_M10_6_s VDD_M10_6_b pmos l=1u w=8u
R_N004_6_M11_6_d N004_6 N004_6_M11_6_d 0.01
R_B_6_M11_6_g B_6 B_6_M11_6_g 0.01
R_N006_6_M11_6_s N006_6 N006_6_M11_6_s 0.01
R_VDD_M11_6_b VDD VDD_M11_6_b 0.01
M11_6 N004_6_M11_6_d B_6_M11_6_g N006_6_M11_6_s VDD_M11_6_b pmos l=1u w=8u
R_N006_6_M12_6_d N006_6 N006_6_M12_6_d 0.01
R_C_6_M12_6_g C_6 C_6_M12_6_g 0.01
R_N007_6_M12_6_s N007_6 N007_6_M12_6_s 0.01
R_VDD_M12_6_b VDD VDD_M12_6_b 0.01
M12_6 N006_6_M12_6_d C_6_M12_6_g N007_6_M12_6_s VDD_M12_6_b pmos l=1u w=8u
R_N007_6_M13_6_d N007_6 N007_6_M13_6_d 0.01
R_C_6_M13_6_g C_6 C_6_M13_6_g 0.01
R_N008_6_M13_6_s N008_6 N008_6_M13_6_s 0.01
M13_6 N007_6_M13_6_d C_6_M13_6_g N008_6_M13_6_s 0 nmos l=1u w=8u
R_N008_6_M14_6_d N008_6 N008_6_M14_6_d 0.01
R_B_6_M14_6_g B_6 B_6_M14_6_g 0.01
R_N012_6_M14_6_s N012_6 N012_6_M14_6_s 0.01
M14_6 N008_6_M14_6_d B_6_M14_6_g N012_6_M14_6_s 0 nmos l=1u w=8u
R_N012_6_M15_6_d N012_6 N012_6_M15_6_d 0.01
R_A_6_M15_6_g A_6 A_6_M15_6_g 0.01
M15_6 N012_6_M15_6_d A_6_M15_6_g 0 0 nmos l=1u w=8u
R_N010_6_M16_6_d N010_6 N010_6_M16_6_d 0.01
R_C_6_M16_6_g C_6 C_6_M16_6_g 0.01
M16_6 N010_6_M16_6_d C_6_M16_6_g 0 0 nmos l=1u w=2u
R_N010_6_M17_6_d N010_6 N010_6_M17_6_d 0.01
R_B_6_M17_6_g B_6 B_6_M17_6_g 0.01
M17_6 N010_6_M17_6_d B_6_M17_6_g 0 0 nmos l=1u w=2u
R_N010_6_M18_6_d N010_6 N010_6_M18_6_d 0.01
R_A_6_M18_6_g A_6 A_6_M18_6_g 0.01
M18_6 N010_6_M18_6_d A_6_M18_6_g 0 0 nmos l=1u w=2u
R_N007_6_M19_6_d N007_6 N007_6_M19_6_d 0.01
R_N005_6_M19_6_g N005_6 N005_6_M19_6_g 0.01
R_N010_6_M19_6_s N010_6 N010_6_M19_6_s 0.01
M19_6 N007_6_M19_6_d N005_6_M19_6_g N010_6_M19_6_s 0 nmos l=1u w=2u
R_N009_6_M20_6_d N009_6 N009_6_M20_6_d 0.01
R_B_6_M20_6_g B_6 B_6_M20_6_g 0.01
M20_6 N009_6_M20_6_d B_6_M20_6_g 0 0 nmos l=1u w=2u
R_N009_6_M21_6_d N009_6 N009_6_M21_6_d 0.01
R_A_6_M21_6_g A_6 A_6_M21_6_g 0.01
M21_6 N009_6_M21_6_d A_6_M21_6_g 0 0 nmos l=1u w=2u
R_N011_6_M22_6_d N011_6 N011_6_M22_6_d 0.01
R_A_6_M22_6_g A_6 A_6_M22_6_g 0.01
M22_6 N011_6_M22_6_d A_6_M22_6_g 0 0 nmos l=1u w=2u
R_N005_6_M23_6_d N005_6 N005_6_M23_6_d 0.01
R_B_6_M23_6_g B_6 B_6_M23_6_g 0.01
R_N011_6_M23_6_s N011_6 N011_6_M23_6_s 0.01
M23_6 N005_6_M23_6_d B_6_M23_6_g N011_6_M23_6_s 0 nmos l=1u w=2u
R_N005_6_M24_6_d N005_6 N005_6_M24_6_d 0.01
R_C_6_M24_6_g C_6 C_6_M24_6_g 0.01
R_N009_6_M24_6_s N009_6 N009_6_M24_6_s 0.01
M24_6 N005_6_M24_6_d C_6_M24_6_g N009_6_M24_6_s 0 nmos l=1u w=2u
R_C_7_M25_6_d C_7 C_7_M25_6_d 0.01
R_N005_6_M25_6_g N005_6 N005_6_M25_6_g 0.01
M25_6 C_7_M25_6_d N005_6_M25_6_g 0 0 nmos l=1u w=1u
R_N002_6_M26_6_d N002_6 N002_6_M26_6_d 0.01
R_N005_6_M26_6_g N005_6 N005_6_M26_6_g 0.01
R_N007_6_M26_6_s N007_6 N007_6_M26_6_s 0.01
R_VDD_M26_6_b VDD VDD_M26_6_b 0.01
M26_6 N002_6_M26_6_d N005_6_M26_6_g N007_6_M26_6_s VDD_M26_6_b pmos l=1u w=4u
R_VDD_M27_6_d VDD VDD_M27_6_d 0.01
R_N007_6_M27_6_g N007_6 N007_6_M27_6_g 0.01
R_S_6_M27_6_s S_6 S_6_M27_6_s 0.01
R_VDD_M27_6_b VDD VDD_M27_6_b 0.01
M27_6 VDD_M27_6_d N007_6_M27_6_g S_6_M27_6_s VDD_M27_6_b pmos l=1u w=2u
R_S_6_M28_6_d S_6 S_6_M28_6_d 0.01
R_N007_6_M28_6_g N007_6 N007_6_M28_6_g 0.01
M28_6 S_6_M28_6_d N007_6_M28_6_g 0 0 nmos l=1u w=1u
C_S_6 S_6 0 1f
* --- Bit 7 ---
R_VDD_M1_7_d VDD VDD_M1_7_d 0.01
R_A_7_M1_7_g A_7 A_7_M1_7_g 0.01
R_N003_7_M1_7_s N003_7 N003_7_M1_7_s 0.01
R_VDD_M1_7_b VDD VDD_M1_7_b 0.01
M1_7 VDD_M1_7_d A_7_M1_7_g N003_7_M1_7_s VDD_M1_7_b pmos l=1u w=4u
R_N003_7_M2_7_d N003_7 N003_7_M2_7_d 0.01
R_B_7_M2_7_g B_7 B_7_M2_7_g 0.01
R_N005_7_M2_7_s N005_7 N005_7_M2_7_s 0.01
R_VDD_M2_7_b VDD VDD_M2_7_b 0.01
M2_7 N003_7_M2_7_d B_7_M2_7_g N005_7_M2_7_s VDD_M2_7_b pmos l=1u w=4u
R_VDD_M3_7_d VDD VDD_M3_7_d 0.01
R_A_7_M3_7_g A_7 A_7_M3_7_g 0.01
R_N001_7_M3_7_s N001_7 N001_7_M3_7_s 0.01
R_VDD_M3_7_b VDD VDD_M3_7_b 0.01
M3_7 VDD_M3_7_d A_7_M3_7_g N001_7_M3_7_s VDD_M3_7_b pmos l=1u w=4u
R_N001_7_M4_7_d N001_7 N001_7_M4_7_d 0.01
R_C_7_M4_7_g C_7 C_7_M4_7_g 0.01
R_N005_7_M4_7_s N005_7 N005_7_M4_7_s 0.01
R_VDD_M4_7_b VDD VDD_M4_7_b 0.01
M4_7 N001_7_M4_7_d C_7_M4_7_g N005_7_M4_7_s VDD_M4_7_b pmos l=1u w=4u
R_VDD_M5_7_d VDD VDD_M5_7_d 0.01
R_B_7_M5_7_g B_7 B_7_M5_7_g 0.01
R_N001_7_M5_7_s N001_7 N001_7_M5_7_s 0.01
R_VDD_M5_7_b VDD VDD_M5_7_b 0.01
M5_7 VDD_M5_7_d B_7_M5_7_g N001_7_M5_7_s VDD_M5_7_b pmos l=1u w=4u
R_VDD_M6_7_d VDD VDD_M6_7_d 0.01
R_N005_7_M6_7_g N005_7 N005_7_M6_7_g 0.01
R_C_8_M6_7_s C_8 C_8_M6_7_s 0.01
R_VDD_M6_7_b VDD VDD_M6_7_b 0.01
M6_7 VDD_M6_7_d N005_7_M6_7_g C_8_M6_7_s VDD_M6_7_b pmos l=1u w=2u
R_VDD_M7_7_d VDD VDD_M7_7_d 0.01
R_A_7_M7_7_g A_7 A_7_M7_7_g 0.01
R_N002_7_M7_7_s N002_7 N002_7_M7_7_s 0.01
R_VDD_M7_7_b VDD VDD_M7_7_b 0.01
M7_7 VDD_M7_7_d A_7_M7_7_g N002_7_M7_7_s VDD_M7_7_b pmos l=1u w=4u
R_VDD_M8_7_d VDD VDD_M8_7_d 0.01
R_B_7_M8_7_g B_7 B_7_M8_7_g 0.01
R_N002_7_M8_7_s N002_7 N002_7_M8_7_s 0.01
R_VDD_M8_7_b VDD VDD_M8_7_b 0.01
M8_7 VDD_M8_7_d B_7_M8_7_g N002_7_M8_7_s VDD_M8_7_b pmos l=1u w=4u
R_VDD_M9_7_d VDD VDD_M9_7_d 0.01
R_C_7_M9_7_g C_7 C_7_M9_7_g 0.01
R_N002_7_M9_7_s N002_7 N002_7_M9_7_s 0.01
R_VDD_M9_7_b VDD VDD_M9_7_b 0.01
M9_7 VDD_M9_7_d C_7_M9_7_g N002_7_M9_7_s VDD_M9_7_b pmos l=1u w=4u
R_VDD_M10_7_d VDD VDD_M10_7_d 0.01
R_A_7_M10_7_g A_7 A_7_M10_7_g 0.01
R_N004_7_M10_7_s N004_7 N004_7_M10_7_s 0.01
R_VDD_M10_7_b VDD VDD_M10_7_b 0.01
M10_7 VDD_M10_7_d A_7_M10_7_g N004_7_M10_7_s VDD_M10_7_b pmos l=1u w=8u
R_N004_7_M11_7_d N004_7 N004_7_M11_7_d 0.01
R_B_7_M11_7_g B_7 B_7_M11_7_g 0.01
R_N006_7_M11_7_s N006_7 N006_7_M11_7_s 0.01
R_VDD_M11_7_b VDD VDD_M11_7_b 0.01
M11_7 N004_7_M11_7_d B_7_M11_7_g N006_7_M11_7_s VDD_M11_7_b pmos l=1u w=8u
R_N006_7_M12_7_d N006_7 N006_7_M12_7_d 0.01
R_C_7_M12_7_g C_7 C_7_M12_7_g 0.01
R_N007_7_M12_7_s N007_7 N007_7_M12_7_s 0.01
R_VDD_M12_7_b VDD VDD_M12_7_b 0.01
M12_7 N006_7_M12_7_d C_7_M12_7_g N007_7_M12_7_s VDD_M12_7_b pmos l=1u w=8u
R_N007_7_M13_7_d N007_7 N007_7_M13_7_d 0.01
R_C_7_M13_7_g C_7 C_7_M13_7_g 0.01
R_N008_7_M13_7_s N008_7 N008_7_M13_7_s 0.01
M13_7 N007_7_M13_7_d C_7_M13_7_g N008_7_M13_7_s 0 nmos l=1u w=8u
R_N008_7_M14_7_d N008_7 N008_7_M14_7_d 0.01
R_B_7_M14_7_g B_7 B_7_M14_7_g 0.01
R_N012_7_M14_7_s N012_7 N012_7_M14_7_s 0.01
M14_7 N008_7_M14_7_d B_7_M14_7_g N012_7_M14_7_s 0 nmos l=1u w=8u
R_N012_7_M15_7_d N012_7 N012_7_M15_7_d 0.01
R_A_7_M15_7_g A_7 A_7_M15_7_g 0.01
M15_7 N012_7_M15_7_d A_7_M15_7_g 0 0 nmos l=1u w=8u
R_N010_7_M16_7_d N010_7 N010_7_M16_7_d 0.01
R_C_7_M16_7_g C_7 C_7_M16_7_g 0.01
M16_7 N010_7_M16_7_d C_7_M16_7_g 0 0 nmos l=1u w=2u
R_N010_7_M17_7_d N010_7 N010_7_M17_7_d 0.01
R_B_7_M17_7_g B_7 B_7_M17_7_g 0.01
M17_7 N010_7_M17_7_d B_7_M17_7_g 0 0 nmos l=1u w=2u
R_N010_7_M18_7_d N010_7 N010_7_M18_7_d 0.01
R_A_7_M18_7_g A_7 A_7_M18_7_g 0.01
M18_7 N010_7_M18_7_d A_7_M18_7_g 0 0 nmos l=1u w=2u
R_N007_7_M19_7_d N007_7 N007_7_M19_7_d 0.01
R_N005_7_M19_7_g N005_7 N005_7_M19_7_g 0.01
R_N010_7_M19_7_s N010_7 N010_7_M19_7_s 0.01
M19_7 N007_7_M19_7_d N005_7_M19_7_g N010_7_M19_7_s 0 nmos l=1u w=2u
R_N009_7_M20_7_d N009_7 N009_7_M20_7_d 0.01
R_B_7_M20_7_g B_7 B_7_M20_7_g 0.01
M20_7 N009_7_M20_7_d B_7_M20_7_g 0 0 nmos l=1u w=2u
R_N009_7_M21_7_d N009_7 N009_7_M21_7_d 0.01
R_A_7_M21_7_g A_7 A_7_M21_7_g 0.01
M21_7 N009_7_M21_7_d A_7_M21_7_g 0 0 nmos l=1u w=2u
R_N011_7_M22_7_d N011_7 N011_7_M22_7_d 0.01
R_A_7_M22_7_g A_7 A_7_M22_7_g 0.01
M22_7 N011_7_M22_7_d A_7_M22_7_g 0 0 nmos l=1u w=2u
R_N005_7_M23_7_d N005_7 N005_7_M23_7_d 0.01
R_B_7_M23_7_g B_7 B_7_M23_7_g 0.01
R_N011_7_M23_7_s N011_7 N011_7_M23_7_s 0.01
M23_7 N005_7_M23_7_d B_7_M23_7_g N011_7_M23_7_s 0 nmos l=1u w=2u
R_N005_7_M24_7_d N005_7 N005_7_M24_7_d 0.01
R_C_7_M24_7_g C_7 C_7_M24_7_g 0.01
R_N009_7_M24_7_s N009_7 N009_7_M24_7_s 0.01
M24_7 N005_7_M24_7_d C_7_M24_7_g N009_7_M24_7_s 0 nmos l=1u w=2u
R_C_8_M25_7_d C_8 C_8_M25_7_d 0.01
R_N005_7_M25_7_g N005_7 N005_7_M25_7_g 0.01
M25_7 C_8_M25_7_d N005_7_M25_7_g 0 0 nmos l=1u w=1u
R_N002_7_M26_7_d N002_7 N002_7_M26_7_d 0.01
R_N005_7_M26_7_g N005_7 N005_7_M26_7_g 0.01
R_N007_7_M26_7_s N007_7 N007_7_M26_7_s 0.01
R_VDD_M26_7_b VDD VDD_M26_7_b 0.01
M26_7 N002_7_M26_7_d N005_7_M26_7_g N007_7_M26_7_s VDD_M26_7_b pmos l=1u w=4u
R_VDD_M27_7_d VDD VDD_M27_7_d 0.01
R_N007_7_M27_7_g N007_7 N007_7_M27_7_g 0.01
R_S_7_M27_7_s S_7 S_7_M27_7_s 0.01
R_VDD_M27_7_b VDD VDD_M27_7_b 0.01
M27_7 VDD_M27_7_d N007_7_M27_7_g S_7_M27_7_s VDD_M27_7_b pmos l=1u w=2u
R_S_7_M28_7_d S_7 S_7_M28_7_d 0.01
R_N007_7_M28_7_g N007_7 N007_7_M28_7_g 0.01
M28_7 S_7_M28_7_d N007_7_M28_7_g 0 0 nmos l=1u w=1u
C_S_7 S_7 0 1f
* --- Bit 8 ---
R_VDD_M1_8_d VDD VDD_M1_8_d 0.01
R_A_8_M1_8_g A_8 A_8_M1_8_g 0.01
R_N003_8_M1_8_s N003_8 N003_8_M1_8_s 0.01
R_VDD_M1_8_b VDD VDD_M1_8_b 0.01
M1_8 VDD_M1_8_d A_8_M1_8_g N003_8_M1_8_s VDD_M1_8_b pmos l=1u w=4u
R_N003_8_M2_8_d N003_8 N003_8_M2_8_d 0.01
R_B_8_M2_8_g B_8 B_8_M2_8_g 0.01
R_N005_8_M2_8_s N005_8 N005_8_M2_8_s 0.01
R_VDD_M2_8_b VDD VDD_M2_8_b 0.01
M2_8 N003_8_M2_8_d B_8_M2_8_g N005_8_M2_8_s VDD_M2_8_b pmos l=1u w=4u
R_VDD_M3_8_d VDD VDD_M3_8_d 0.01
R_A_8_M3_8_g A_8 A_8_M3_8_g 0.01
R_N001_8_M3_8_s N001_8 N001_8_M3_8_s 0.01
R_VDD_M3_8_b VDD VDD_M3_8_b 0.01
M3_8 VDD_M3_8_d A_8_M3_8_g N001_8_M3_8_s VDD_M3_8_b pmos l=1u w=4u
R_N001_8_M4_8_d N001_8 N001_8_M4_8_d 0.01
R_C_8_M4_8_g C_8 C_8_M4_8_g 0.01
R_N005_8_M4_8_s N005_8 N005_8_M4_8_s 0.01
R_VDD_M4_8_b VDD VDD_M4_8_b 0.01
M4_8 N001_8_M4_8_d C_8_M4_8_g N005_8_M4_8_s VDD_M4_8_b pmos l=1u w=4u
R_VDD_M5_8_d VDD VDD_M5_8_d 0.01
R_B_8_M5_8_g B_8 B_8_M5_8_g 0.01
R_N001_8_M5_8_s N001_8 N001_8_M5_8_s 0.01
R_VDD_M5_8_b VDD VDD_M5_8_b 0.01
M5_8 VDD_M5_8_d B_8_M5_8_g N001_8_M5_8_s VDD_M5_8_b pmos l=1u w=4u
R_VDD_M6_8_d VDD VDD_M6_8_d 0.01
R_N005_8_M6_8_g N005_8 N005_8_M6_8_g 0.01
R_C_9_M6_8_s C_9 C_9_M6_8_s 0.01
R_VDD_M6_8_b VDD VDD_M6_8_b 0.01
M6_8 VDD_M6_8_d N005_8_M6_8_g C_9_M6_8_s VDD_M6_8_b pmos l=1u w=2u
R_VDD_M7_8_d VDD VDD_M7_8_d 0.01
R_A_8_M7_8_g A_8 A_8_M7_8_g 0.01
R_N002_8_M7_8_s N002_8 N002_8_M7_8_s 0.01
R_VDD_M7_8_b VDD VDD_M7_8_b 0.01
M7_8 VDD_M7_8_d A_8_M7_8_g N002_8_M7_8_s VDD_M7_8_b pmos l=1u w=4u
R_VDD_M8_8_d VDD VDD_M8_8_d 0.01
R_B_8_M8_8_g B_8 B_8_M8_8_g 0.01
R_N002_8_M8_8_s N002_8 N002_8_M8_8_s 0.01
R_VDD_M8_8_b VDD VDD_M8_8_b 0.01
M8_8 VDD_M8_8_d B_8_M8_8_g N002_8_M8_8_s VDD_M8_8_b pmos l=1u w=4u
R_VDD_M9_8_d VDD VDD_M9_8_d 0.01
R_C_8_M9_8_g C_8 C_8_M9_8_g 0.01
R_N002_8_M9_8_s N002_8 N002_8_M9_8_s 0.01
R_VDD_M9_8_b VDD VDD_M9_8_b 0.01
M9_8 VDD_M9_8_d C_8_M9_8_g N002_8_M9_8_s VDD_M9_8_b pmos l=1u w=4u
R_VDD_M10_8_d VDD VDD_M10_8_d 0.01
R_A_8_M10_8_g A_8 A_8_M10_8_g 0.01
R_N004_8_M10_8_s N004_8 N004_8_M10_8_s 0.01
R_VDD_M10_8_b VDD VDD_M10_8_b 0.01
M10_8 VDD_M10_8_d A_8_M10_8_g N004_8_M10_8_s VDD_M10_8_b pmos l=1u w=8u
R_N004_8_M11_8_d N004_8 N004_8_M11_8_d 0.01
R_B_8_M11_8_g B_8 B_8_M11_8_g 0.01
R_N006_8_M11_8_s N006_8 N006_8_M11_8_s 0.01
R_VDD_M11_8_b VDD VDD_M11_8_b 0.01
M11_8 N004_8_M11_8_d B_8_M11_8_g N006_8_M11_8_s VDD_M11_8_b pmos l=1u w=8u
R_N006_8_M12_8_d N006_8 N006_8_M12_8_d 0.01
R_C_8_M12_8_g C_8 C_8_M12_8_g 0.01
R_N007_8_M12_8_s N007_8 N007_8_M12_8_s 0.01
R_VDD_M12_8_b VDD VDD_M12_8_b 0.01
M12_8 N006_8_M12_8_d C_8_M12_8_g N007_8_M12_8_s VDD_M12_8_b pmos l=1u w=8u
R_N007_8_M13_8_d N007_8 N007_8_M13_8_d 0.01
R_C_8_M13_8_g C_8 C_8_M13_8_g 0.01
R_N008_8_M13_8_s N008_8 N008_8_M13_8_s 0.01
M13_8 N007_8_M13_8_d C_8_M13_8_g N008_8_M13_8_s 0 nmos l=1u w=8u
R_N008_8_M14_8_d N008_8 N008_8_M14_8_d 0.01
R_B_8_M14_8_g B_8 B_8_M14_8_g 0.01
R_N012_8_M14_8_s N012_8 N012_8_M14_8_s 0.01
M14_8 N008_8_M14_8_d B_8_M14_8_g N012_8_M14_8_s 0 nmos l=1u w=8u
R_N012_8_M15_8_d N012_8 N012_8_M15_8_d 0.01
R_A_8_M15_8_g A_8 A_8_M15_8_g 0.01
M15_8 N012_8_M15_8_d A_8_M15_8_g 0 0 nmos l=1u w=8u
R_N010_8_M16_8_d N010_8 N010_8_M16_8_d 0.01
R_C_8_M16_8_g C_8 C_8_M16_8_g 0.01
M16_8 N010_8_M16_8_d C_8_M16_8_g 0 0 nmos l=1u w=2u
R_N010_8_M17_8_d N010_8 N010_8_M17_8_d 0.01
R_B_8_M17_8_g B_8 B_8_M17_8_g 0.01
M17_8 N010_8_M17_8_d B_8_M17_8_g 0 0 nmos l=1u w=2u
R_N010_8_M18_8_d N010_8 N010_8_M18_8_d 0.01
R_A_8_M18_8_g A_8 A_8_M18_8_g 0.01
M18_8 N010_8_M18_8_d A_8_M18_8_g 0 0 nmos l=1u w=2u
R_N007_8_M19_8_d N007_8 N007_8_M19_8_d 0.01
R_N005_8_M19_8_g N005_8 N005_8_M19_8_g 0.01
R_N010_8_M19_8_s N010_8 N010_8_M19_8_s 0.01
M19_8 N007_8_M19_8_d N005_8_M19_8_g N010_8_M19_8_s 0 nmos l=1u w=2u
R_N009_8_M20_8_d N009_8 N009_8_M20_8_d 0.01
R_B_8_M20_8_g B_8 B_8_M20_8_g 0.01
M20_8 N009_8_M20_8_d B_8_M20_8_g 0 0 nmos l=1u w=2u
R_N009_8_M21_8_d N009_8 N009_8_M21_8_d 0.01
R_A_8_M21_8_g A_8 A_8_M21_8_g 0.01
M21_8 N009_8_M21_8_d A_8_M21_8_g 0 0 nmos l=1u w=2u
R_N011_8_M22_8_d N011_8 N011_8_M22_8_d 0.01
R_A_8_M22_8_g A_8 A_8_M22_8_g 0.01
M22_8 N011_8_M22_8_d A_8_M22_8_g 0 0 nmos l=1u w=2u
R_N005_8_M23_8_d N005_8 N005_8_M23_8_d 0.01
R_B_8_M23_8_g B_8 B_8_M23_8_g 0.01
R_N011_8_M23_8_s N011_8 N011_8_M23_8_s 0.01
M23_8 N005_8_M23_8_d B_8_M23_8_g N011_8_M23_8_s 0 nmos l=1u w=2u
R_N005_8_M24_8_d N005_8 N005_8_M24_8_d 0.01
R_C_8_M24_8_g C_8 C_8_M24_8_g 0.01
R_N009_8_M24_8_s N009_8 N009_8_M24_8_s 0.01
M24_8 N005_8_M24_8_d C_8_M24_8_g N009_8_M24_8_s 0 nmos l=1u w=2u
R_C_9_M25_8_d C_9 C_9_M25_8_d 0.01
R_N005_8_M25_8_g N005_8 N005_8_M25_8_g 0.01
M25_8 C_9_M25_8_d N005_8_M25_8_g 0 0 nmos l=1u w=1u
R_N002_8_M26_8_d N002_8 N002_8_M26_8_d 0.01
R_N005_8_M26_8_g N005_8 N005_8_M26_8_g 0.01
R_N007_8_M26_8_s N007_8 N007_8_M26_8_s 0.01
R_VDD_M26_8_b VDD VDD_M26_8_b 0.01
M26_8 N002_8_M26_8_d N005_8_M26_8_g N007_8_M26_8_s VDD_M26_8_b pmos l=1u w=4u
R_VDD_M27_8_d VDD VDD_M27_8_d 0.01
R_N007_8_M27_8_g N007_8 N007_8_M27_8_g 0.01
R_S_8_M27_8_s S_8 S_8_M27_8_s 0.01
R_VDD_M27_8_b VDD VDD_M27_8_b 0.01
M27_8 VDD_M27_8_d N007_8_M27_8_g S_8_M27_8_s VDD_M27_8_b pmos l=1u w=2u
R_S_8_M28_8_d S_8 S_8_M28_8_d 0.01
R_N007_8_M28_8_g N007_8 N007_8_M28_8_g 0.01
M28_8 S_8_M28_8_d N007_8_M28_8_g 0 0 nmos l=1u w=1u
C_S_8 S_8 0 1f
* --- Bit 9 ---
R_VDD_M1_9_d VDD VDD_M1_9_d 0.01
R_A_9_M1_9_g A_9 A_9_M1_9_g 0.01
R_N003_9_M1_9_s N003_9 N003_9_M1_9_s 0.01
R_VDD_M1_9_b VDD VDD_M1_9_b 0.01
M1_9 VDD_M1_9_d A_9_M1_9_g N003_9_M1_9_s VDD_M1_9_b pmos l=1u w=4u
R_N003_9_M2_9_d N003_9 N003_9_M2_9_d 0.01
R_B_9_M2_9_g B_9 B_9_M2_9_g 0.01
R_N005_9_M2_9_s N005_9 N005_9_M2_9_s 0.01
R_VDD_M2_9_b VDD VDD_M2_9_b 0.01
M2_9 N003_9_M2_9_d B_9_M2_9_g N005_9_M2_9_s VDD_M2_9_b pmos l=1u w=4u
R_VDD_M3_9_d VDD VDD_M3_9_d 0.01
R_A_9_M3_9_g A_9 A_9_M3_9_g 0.01
R_N001_9_M3_9_s N001_9 N001_9_M3_9_s 0.01
R_VDD_M3_9_b VDD VDD_M3_9_b 0.01
M3_9 VDD_M3_9_d A_9_M3_9_g N001_9_M3_9_s VDD_M3_9_b pmos l=1u w=4u
R_N001_9_M4_9_d N001_9 N001_9_M4_9_d 0.01
R_C_9_M4_9_g C_9 C_9_M4_9_g 0.01
R_N005_9_M4_9_s N005_9 N005_9_M4_9_s 0.01
R_VDD_M4_9_b VDD VDD_M4_9_b 0.01
M4_9 N001_9_M4_9_d C_9_M4_9_g N005_9_M4_9_s VDD_M4_9_b pmos l=1u w=4u
R_VDD_M5_9_d VDD VDD_M5_9_d 0.01
R_B_9_M5_9_g B_9 B_9_M5_9_g 0.01
R_N001_9_M5_9_s N001_9 N001_9_M5_9_s 0.01
R_VDD_M5_9_b VDD VDD_M5_9_b 0.01
M5_9 VDD_M5_9_d B_9_M5_9_g N001_9_M5_9_s VDD_M5_9_b pmos l=1u w=4u
R_VDD_M6_9_d VDD VDD_M6_9_d 0.01
R_N005_9_M6_9_g N005_9 N005_9_M6_9_g 0.01
R_C_10_M6_9_s C_10 C_10_M6_9_s 0.01
R_VDD_M6_9_b VDD VDD_M6_9_b 0.01
M6_9 VDD_M6_9_d N005_9_M6_9_g C_10_M6_9_s VDD_M6_9_b pmos l=1u w=2u
R_VDD_M7_9_d VDD VDD_M7_9_d 0.01
R_A_9_M7_9_g A_9 A_9_M7_9_g 0.01
R_N002_9_M7_9_s N002_9 N002_9_M7_9_s 0.01
R_VDD_M7_9_b VDD VDD_M7_9_b 0.01
M7_9 VDD_M7_9_d A_9_M7_9_g N002_9_M7_9_s VDD_M7_9_b pmos l=1u w=4u
R_VDD_M8_9_d VDD VDD_M8_9_d 0.01
R_B_9_M8_9_g B_9 B_9_M8_9_g 0.01
R_N002_9_M8_9_s N002_9 N002_9_M8_9_s 0.01
R_VDD_M8_9_b VDD VDD_M8_9_b 0.01
M8_9 VDD_M8_9_d B_9_M8_9_g N002_9_M8_9_s VDD_M8_9_b pmos l=1u w=4u
R_VDD_M9_9_d VDD VDD_M9_9_d 0.01
R_C_9_M9_9_g C_9 C_9_M9_9_g 0.01
R_N002_9_M9_9_s N002_9 N002_9_M9_9_s 0.01
R_VDD_M9_9_b VDD VDD_M9_9_b 0.01
M9_9 VDD_M9_9_d C_9_M9_9_g N002_9_M9_9_s VDD_M9_9_b pmos l=1u w=4u
R_VDD_M10_9_d VDD VDD_M10_9_d 0.01
R_A_9_M10_9_g A_9 A_9_M10_9_g 0.01
R_N004_9_M10_9_s N004_9 N004_9_M10_9_s 0.01
R_VDD_M10_9_b VDD VDD_M10_9_b 0.01
M10_9 VDD_M10_9_d A_9_M10_9_g N004_9_M10_9_s VDD_M10_9_b pmos l=1u w=8u
R_N004_9_M11_9_d N004_9 N004_9_M11_9_d 0.01
R_B_9_M11_9_g B_9 B_9_M11_9_g 0.01
R_N006_9_M11_9_s N006_9 N006_9_M11_9_s 0.01
R_VDD_M11_9_b VDD VDD_M11_9_b 0.01
M11_9 N004_9_M11_9_d B_9_M11_9_g N006_9_M11_9_s VDD_M11_9_b pmos l=1u w=8u
R_N006_9_M12_9_d N006_9 N006_9_M12_9_d 0.01
R_C_9_M12_9_g C_9 C_9_M12_9_g 0.01
R_N007_9_M12_9_s N007_9 N007_9_M12_9_s 0.01
R_VDD_M12_9_b VDD VDD_M12_9_b 0.01
M12_9 N006_9_M12_9_d C_9_M12_9_g N007_9_M12_9_s VDD_M12_9_b pmos l=1u w=8u
R_N007_9_M13_9_d N007_9 N007_9_M13_9_d 0.01
R_C_9_M13_9_g C_9 C_9_M13_9_g 0.01
R_N008_9_M13_9_s N008_9 N008_9_M13_9_s 0.01
M13_9 N007_9_M13_9_d C_9_M13_9_g N008_9_M13_9_s 0 nmos l=1u w=8u
R_N008_9_M14_9_d N008_9 N008_9_M14_9_d 0.01
R_B_9_M14_9_g B_9 B_9_M14_9_g 0.01
R_N012_9_M14_9_s N012_9 N012_9_M14_9_s 0.01
M14_9 N008_9_M14_9_d B_9_M14_9_g N012_9_M14_9_s 0 nmos l=1u w=8u
R_N012_9_M15_9_d N012_9 N012_9_M15_9_d 0.01
R_A_9_M15_9_g A_9 A_9_M15_9_g 0.01
M15_9 N012_9_M15_9_d A_9_M15_9_g 0 0 nmos l=1u w=8u
R_N010_9_M16_9_d N010_9 N010_9_M16_9_d 0.01
R_C_9_M16_9_g C_9 C_9_M16_9_g 0.01
M16_9 N010_9_M16_9_d C_9_M16_9_g 0 0 nmos l=1u w=2u
R_N010_9_M17_9_d N010_9 N010_9_M17_9_d 0.01
R_B_9_M17_9_g B_9 B_9_M17_9_g 0.01
M17_9 N010_9_M17_9_d B_9_M17_9_g 0 0 nmos l=1u w=2u
R_N010_9_M18_9_d N010_9 N010_9_M18_9_d 0.01
R_A_9_M18_9_g A_9 A_9_M18_9_g 0.01
M18_9 N010_9_M18_9_d A_9_M18_9_g 0 0 nmos l=1u w=2u
R_N007_9_M19_9_d N007_9 N007_9_M19_9_d 0.01
R_N005_9_M19_9_g N005_9 N005_9_M19_9_g 0.01
R_N010_9_M19_9_s N010_9 N010_9_M19_9_s 0.01
M19_9 N007_9_M19_9_d N005_9_M19_9_g N010_9_M19_9_s 0 nmos l=1u w=2u
R_N009_9_M20_9_d N009_9 N009_9_M20_9_d 0.01
R_B_9_M20_9_g B_9 B_9_M20_9_g 0.01
M20_9 N009_9_M20_9_d B_9_M20_9_g 0 0 nmos l=1u w=2u
R_N009_9_M21_9_d N009_9 N009_9_M21_9_d 0.01
R_A_9_M21_9_g A_9 A_9_M21_9_g 0.01
M21_9 N009_9_M21_9_d A_9_M21_9_g 0 0 nmos l=1u w=2u
R_N011_9_M22_9_d N011_9 N011_9_M22_9_d 0.01
R_A_9_M22_9_g A_9 A_9_M22_9_g 0.01
M22_9 N011_9_M22_9_d A_9_M22_9_g 0 0 nmos l=1u w=2u
R_N005_9_M23_9_d N005_9 N005_9_M23_9_d 0.01
R_B_9_M23_9_g B_9 B_9_M23_9_g 0.01
R_N011_9_M23_9_s N011_9 N011_9_M23_9_s 0.01
M23_9 N005_9_M23_9_d B_9_M23_9_g N011_9_M23_9_s 0 nmos l=1u w=2u
R_N005_9_M24_9_d N005_9 N005_9_M24_9_d 0.01
R_C_9_M24_9_g C_9 C_9_M24_9_g 0.01
R_N009_9_M24_9_s N009_9 N009_9_M24_9_s 0.01
M24_9 N005_9_M24_9_d C_9_M24_9_g N009_9_M24_9_s 0 nmos l=1u w=2u
R_C_10_M25_9_d C_10 C_10_M25_9_d 0.01
R_N005_9_M25_9_g N005_9 N005_9_M25_9_g 0.01
M25_9 C_10_M25_9_d N005_9_M25_9_g 0 0 nmos l=1u w=1u
R_N002_9_M26_9_d N002_9 N002_9_M26_9_d 0.01
R_N005_9_M26_9_g N005_9 N005_9_M26_9_g 0.01
R_N007_9_M26_9_s N007_9 N007_9_M26_9_s 0.01
R_VDD_M26_9_b VDD VDD_M26_9_b 0.01
M26_9 N002_9_M26_9_d N005_9_M26_9_g N007_9_M26_9_s VDD_M26_9_b pmos l=1u w=4u
R_VDD_M27_9_d VDD VDD_M27_9_d 0.01
R_N007_9_M27_9_g N007_9 N007_9_M27_9_g 0.01
R_S_9_M27_9_s S_9 S_9_M27_9_s 0.01
R_VDD_M27_9_b VDD VDD_M27_9_b 0.01
M27_9 VDD_M27_9_d N007_9_M27_9_g S_9_M27_9_s VDD_M27_9_b pmos l=1u w=2u
R_S_9_M28_9_d S_9 S_9_M28_9_d 0.01
R_N007_9_M28_9_g N007_9 N007_9_M28_9_g 0.01
M28_9 S_9_M28_9_d N007_9_M28_9_g 0 0 nmos l=1u w=1u
C_S_9 S_9 0 1f
* --- Bit 10 ---
R_VDD_M1_10_d VDD VDD_M1_10_d 0.01
R_A_10_M1_10_g A_10 A_10_M1_10_g 0.01
R_N003_10_M1_10_s N003_10 N003_10_M1_10_s 0.01
R_VDD_M1_10_b VDD VDD_M1_10_b 0.01
M1_10 VDD_M1_10_d A_10_M1_10_g N003_10_M1_10_s VDD_M1_10_b pmos l=1u w=4u
R_N003_10_M2_10_d N003_10 N003_10_M2_10_d 0.01
R_B_10_M2_10_g B_10 B_10_M2_10_g 0.01
R_N005_10_M2_10_s N005_10 N005_10_M2_10_s 0.01
R_VDD_M2_10_b VDD VDD_M2_10_b 0.01
M2_10 N003_10_M2_10_d B_10_M2_10_g N005_10_M2_10_s VDD_M2_10_b pmos l=1u w=4u
R_VDD_M3_10_d VDD VDD_M3_10_d 0.01
R_A_10_M3_10_g A_10 A_10_M3_10_g 0.01
R_N001_10_M3_10_s N001_10 N001_10_M3_10_s 0.01
R_VDD_M3_10_b VDD VDD_M3_10_b 0.01
M3_10 VDD_M3_10_d A_10_M3_10_g N001_10_M3_10_s VDD_M3_10_b pmos l=1u w=4u
R_N001_10_M4_10_d N001_10 N001_10_M4_10_d 0.01
R_C_10_M4_10_g C_10 C_10_M4_10_g 0.01
R_N005_10_M4_10_s N005_10 N005_10_M4_10_s 0.01
R_VDD_M4_10_b VDD VDD_M4_10_b 0.01
M4_10 N001_10_M4_10_d C_10_M4_10_g N005_10_M4_10_s VDD_M4_10_b pmos l=1u w=4u
R_VDD_M5_10_d VDD VDD_M5_10_d 0.01
R_B_10_M5_10_g B_10 B_10_M5_10_g 0.01
R_N001_10_M5_10_s N001_10 N001_10_M5_10_s 0.01
R_VDD_M5_10_b VDD VDD_M5_10_b 0.01
M5_10 VDD_M5_10_d B_10_M5_10_g N001_10_M5_10_s VDD_M5_10_b pmos l=1u w=4u
R_VDD_M6_10_d VDD VDD_M6_10_d 0.01
R_N005_10_M6_10_g N005_10 N005_10_M6_10_g 0.01
R_C_11_M6_10_s C_11 C_11_M6_10_s 0.01
R_VDD_M6_10_b VDD VDD_M6_10_b 0.01
M6_10 VDD_M6_10_d N005_10_M6_10_g C_11_M6_10_s VDD_M6_10_b pmos l=1u w=2u
R_VDD_M7_10_d VDD VDD_M7_10_d 0.01
R_A_10_M7_10_g A_10 A_10_M7_10_g 0.01
R_N002_10_M7_10_s N002_10 N002_10_M7_10_s 0.01
R_VDD_M7_10_b VDD VDD_M7_10_b 0.01
M7_10 VDD_M7_10_d A_10_M7_10_g N002_10_M7_10_s VDD_M7_10_b pmos l=1u w=4u
R_VDD_M8_10_d VDD VDD_M8_10_d 0.01
R_B_10_M8_10_g B_10 B_10_M8_10_g 0.01
R_N002_10_M8_10_s N002_10 N002_10_M8_10_s 0.01
R_VDD_M8_10_b VDD VDD_M8_10_b 0.01
M8_10 VDD_M8_10_d B_10_M8_10_g N002_10_M8_10_s VDD_M8_10_b pmos l=1u w=4u
R_VDD_M9_10_d VDD VDD_M9_10_d 0.01
R_C_10_M9_10_g C_10 C_10_M9_10_g 0.01
R_N002_10_M9_10_s N002_10 N002_10_M9_10_s 0.01
R_VDD_M9_10_b VDD VDD_M9_10_b 0.01
M9_10 VDD_M9_10_d C_10_M9_10_g N002_10_M9_10_s VDD_M9_10_b pmos l=1u w=4u
R_VDD_M10_10_d VDD VDD_M10_10_d 0.01
R_A_10_M10_10_g A_10 A_10_M10_10_g 0.01
R_N004_10_M10_10_s N004_10 N004_10_M10_10_s 0.01
R_VDD_M10_10_b VDD VDD_M10_10_b 0.01
M10_10 VDD_M10_10_d A_10_M10_10_g N004_10_M10_10_s VDD_M10_10_b pmos l=1u w=8u
R_N004_10_M11_10_d N004_10 N004_10_M11_10_d 0.01
R_B_10_M11_10_g B_10 B_10_M11_10_g 0.01
R_N006_10_M11_10_s N006_10 N006_10_M11_10_s 0.01
R_VDD_M11_10_b VDD VDD_M11_10_b 0.01
M11_10 N004_10_M11_10_d B_10_M11_10_g N006_10_M11_10_s VDD_M11_10_b pmos l=1u w=8u
R_N006_10_M12_10_d N006_10 N006_10_M12_10_d 0.01
R_C_10_M12_10_g C_10 C_10_M12_10_g 0.01
R_N007_10_M12_10_s N007_10 N007_10_M12_10_s 0.01
R_VDD_M12_10_b VDD VDD_M12_10_b 0.01
M12_10 N006_10_M12_10_d C_10_M12_10_g N007_10_M12_10_s VDD_M12_10_b pmos l=1u w=8u
R_N007_10_M13_10_d N007_10 N007_10_M13_10_d 0.01
R_C_10_M13_10_g C_10 C_10_M13_10_g 0.01
R_N008_10_M13_10_s N008_10 N008_10_M13_10_s 0.01
M13_10 N007_10_M13_10_d C_10_M13_10_g N008_10_M13_10_s 0 nmos l=1u w=8u
R_N008_10_M14_10_d N008_10 N008_10_M14_10_d 0.01
R_B_10_M14_10_g B_10 B_10_M14_10_g 0.01
R_N012_10_M14_10_s N012_10 N012_10_M14_10_s 0.01
M14_10 N008_10_M14_10_d B_10_M14_10_g N012_10_M14_10_s 0 nmos l=1u w=8u
R_N012_10_M15_10_d N012_10 N012_10_M15_10_d 0.01
R_A_10_M15_10_g A_10 A_10_M15_10_g 0.01
M15_10 N012_10_M15_10_d A_10_M15_10_g 0 0 nmos l=1u w=8u
R_N010_10_M16_10_d N010_10 N010_10_M16_10_d 0.01
R_C_10_M16_10_g C_10 C_10_M16_10_g 0.01
M16_10 N010_10_M16_10_d C_10_M16_10_g 0 0 nmos l=1u w=2u
R_N010_10_M17_10_d N010_10 N010_10_M17_10_d 0.01
R_B_10_M17_10_g B_10 B_10_M17_10_g 0.01
M17_10 N010_10_M17_10_d B_10_M17_10_g 0 0 nmos l=1u w=2u
R_N010_10_M18_10_d N010_10 N010_10_M18_10_d 0.01
R_A_10_M18_10_g A_10 A_10_M18_10_g 0.01
M18_10 N010_10_M18_10_d A_10_M18_10_g 0 0 nmos l=1u w=2u
R_N007_10_M19_10_d N007_10 N007_10_M19_10_d 0.01
R_N005_10_M19_10_g N005_10 N005_10_M19_10_g 0.01
R_N010_10_M19_10_s N010_10 N010_10_M19_10_s 0.01
M19_10 N007_10_M19_10_d N005_10_M19_10_g N010_10_M19_10_s 0 nmos l=1u w=2u
R_N009_10_M20_10_d N009_10 N009_10_M20_10_d 0.01
R_B_10_M20_10_g B_10 B_10_M20_10_g 0.01
M20_10 N009_10_M20_10_d B_10_M20_10_g 0 0 nmos l=1u w=2u
R_N009_10_M21_10_d N009_10 N009_10_M21_10_d 0.01
R_A_10_M21_10_g A_10 A_10_M21_10_g 0.01
M21_10 N009_10_M21_10_d A_10_M21_10_g 0 0 nmos l=1u w=2u
R_N011_10_M22_10_d N011_10 N011_10_M22_10_d 0.01
R_A_10_M22_10_g A_10 A_10_M22_10_g 0.01
M22_10 N011_10_M22_10_d A_10_M22_10_g 0 0 nmos l=1u w=2u
R_N005_10_M23_10_d N005_10 N005_10_M23_10_d 0.01
R_B_10_M23_10_g B_10 B_10_M23_10_g 0.01
R_N011_10_M23_10_s N011_10 N011_10_M23_10_s 0.01
M23_10 N005_10_M23_10_d B_10_M23_10_g N011_10_M23_10_s 0 nmos l=1u w=2u
R_N005_10_M24_10_d N005_10 N005_10_M24_10_d 0.01
R_C_10_M24_10_g C_10 C_10_M24_10_g 0.01
R_N009_10_M24_10_s N009_10 N009_10_M24_10_s 0.01
M24_10 N005_10_M24_10_d C_10_M24_10_g N009_10_M24_10_s 0 nmos l=1u w=2u
R_C_11_M25_10_d C_11 C_11_M25_10_d 0.01
R_N005_10_M25_10_g N005_10 N005_10_M25_10_g 0.01
M25_10 C_11_M25_10_d N005_10_M25_10_g 0 0 nmos l=1u w=1u
R_N002_10_M26_10_d N002_10 N002_10_M26_10_d 0.01
R_N005_10_M26_10_g N005_10 N005_10_M26_10_g 0.01
R_N007_10_M26_10_s N007_10 N007_10_M26_10_s 0.01
R_VDD_M26_10_b VDD VDD_M26_10_b 0.01
M26_10 N002_10_M26_10_d N005_10_M26_10_g N007_10_M26_10_s VDD_M26_10_b pmos l=1u w=4u
R_VDD_M27_10_d VDD VDD_M27_10_d 0.01
R_N007_10_M27_10_g N007_10 N007_10_M27_10_g 0.01
R_S_10_M27_10_s S_10 S_10_M27_10_s 0.01
R_VDD_M27_10_b VDD VDD_M27_10_b 0.01
M27_10 VDD_M27_10_d N007_10_M27_10_g S_10_M27_10_s VDD_M27_10_b pmos l=1u w=2u
R_S_10_M28_10_d S_10 S_10_M28_10_d 0.01
R_N007_10_M28_10_g N007_10 N007_10_M28_10_g 0.01
M28_10 S_10_M28_10_d N007_10_M28_10_g 0 0 nmos l=1u w=1u
C_S_10 S_10 0 1f
* --- Bit 11 ---
R_VDD_M1_11_d VDD VDD_M1_11_d 0.01
R_A_11_M1_11_g A_11 A_11_M1_11_g 0.01
R_N003_11_M1_11_s N003_11 N003_11_M1_11_s 0.01
R_VDD_M1_11_b VDD VDD_M1_11_b 0.01
M1_11 VDD_M1_11_d A_11_M1_11_g N003_11_M1_11_s VDD_M1_11_b pmos l=1u w=4u
R_N003_11_M2_11_d N003_11 N003_11_M2_11_d 0.01
R_B_11_M2_11_g B_11 B_11_M2_11_g 0.01
R_N005_11_M2_11_s N005_11 N005_11_M2_11_s 0.01
R_VDD_M2_11_b VDD VDD_M2_11_b 0.01
M2_11 N003_11_M2_11_d B_11_M2_11_g N005_11_M2_11_s VDD_M2_11_b pmos l=1u w=4u
R_VDD_M3_11_d VDD VDD_M3_11_d 0.01
R_A_11_M3_11_g A_11 A_11_M3_11_g 0.01
R_N001_11_M3_11_s N001_11 N001_11_M3_11_s 0.01
R_VDD_M3_11_b VDD VDD_M3_11_b 0.01
M3_11 VDD_M3_11_d A_11_M3_11_g N001_11_M3_11_s VDD_M3_11_b pmos l=1u w=4u
R_N001_11_M4_11_d N001_11 N001_11_M4_11_d 0.01
R_C_11_M4_11_g C_11 C_11_M4_11_g 0.01
R_N005_11_M4_11_s N005_11 N005_11_M4_11_s 0.01
R_VDD_M4_11_b VDD VDD_M4_11_b 0.01
M4_11 N001_11_M4_11_d C_11_M4_11_g N005_11_M4_11_s VDD_M4_11_b pmos l=1u w=4u
R_VDD_M5_11_d VDD VDD_M5_11_d 0.01
R_B_11_M5_11_g B_11 B_11_M5_11_g 0.01
R_N001_11_M5_11_s N001_11 N001_11_M5_11_s 0.01
R_VDD_M5_11_b VDD VDD_M5_11_b 0.01
M5_11 VDD_M5_11_d B_11_M5_11_g N001_11_M5_11_s VDD_M5_11_b pmos l=1u w=4u
R_VDD_M6_11_d VDD VDD_M6_11_d 0.01
R_N005_11_M6_11_g N005_11 N005_11_M6_11_g 0.01
R_C_12_M6_11_s C_12 C_12_M6_11_s 0.01
R_VDD_M6_11_b VDD VDD_M6_11_b 0.01
M6_11 VDD_M6_11_d N005_11_M6_11_g C_12_M6_11_s VDD_M6_11_b pmos l=1u w=2u
R_VDD_M7_11_d VDD VDD_M7_11_d 0.01
R_A_11_M7_11_g A_11 A_11_M7_11_g 0.01
R_N002_11_M7_11_s N002_11 N002_11_M7_11_s 0.01
R_VDD_M7_11_b VDD VDD_M7_11_b 0.01
M7_11 VDD_M7_11_d A_11_M7_11_g N002_11_M7_11_s VDD_M7_11_b pmos l=1u w=4u
R_VDD_M8_11_d VDD VDD_M8_11_d 0.01
R_B_11_M8_11_g B_11 B_11_M8_11_g 0.01
R_N002_11_M8_11_s N002_11 N002_11_M8_11_s 0.01
R_VDD_M8_11_b VDD VDD_M8_11_b 0.01
M8_11 VDD_M8_11_d B_11_M8_11_g N002_11_M8_11_s VDD_M8_11_b pmos l=1u w=4u
R_VDD_M9_11_d VDD VDD_M9_11_d 0.01
R_C_11_M9_11_g C_11 C_11_M9_11_g 0.01
R_N002_11_M9_11_s N002_11 N002_11_M9_11_s 0.01
R_VDD_M9_11_b VDD VDD_M9_11_b 0.01
M9_11 VDD_M9_11_d C_11_M9_11_g N002_11_M9_11_s VDD_M9_11_b pmos l=1u w=4u
R_VDD_M10_11_d VDD VDD_M10_11_d 0.01
R_A_11_M10_11_g A_11 A_11_M10_11_g 0.01
R_N004_11_M10_11_s N004_11 N004_11_M10_11_s 0.01
R_VDD_M10_11_b VDD VDD_M10_11_b 0.01
M10_11 VDD_M10_11_d A_11_M10_11_g N004_11_M10_11_s VDD_M10_11_b pmos l=1u w=8u
R_N004_11_M11_11_d N004_11 N004_11_M11_11_d 0.01
R_B_11_M11_11_g B_11 B_11_M11_11_g 0.01
R_N006_11_M11_11_s N006_11 N006_11_M11_11_s 0.01
R_VDD_M11_11_b VDD VDD_M11_11_b 0.01
M11_11 N004_11_M11_11_d B_11_M11_11_g N006_11_M11_11_s VDD_M11_11_b pmos l=1u w=8u
R_N006_11_M12_11_d N006_11 N006_11_M12_11_d 0.01
R_C_11_M12_11_g C_11 C_11_M12_11_g 0.01
R_N007_11_M12_11_s N007_11 N007_11_M12_11_s 0.01
R_VDD_M12_11_b VDD VDD_M12_11_b 0.01
M12_11 N006_11_M12_11_d C_11_M12_11_g N007_11_M12_11_s VDD_M12_11_b pmos l=1u w=8u
R_N007_11_M13_11_d N007_11 N007_11_M13_11_d 0.01
R_C_11_M13_11_g C_11 C_11_M13_11_g 0.01
R_N008_11_M13_11_s N008_11 N008_11_M13_11_s 0.01
M13_11 N007_11_M13_11_d C_11_M13_11_g N008_11_M13_11_s 0 nmos l=1u w=8u
R_N008_11_M14_11_d N008_11 N008_11_M14_11_d 0.01
R_B_11_M14_11_g B_11 B_11_M14_11_g 0.01
R_N012_11_M14_11_s N012_11 N012_11_M14_11_s 0.01
M14_11 N008_11_M14_11_d B_11_M14_11_g N012_11_M14_11_s 0 nmos l=1u w=8u
R_N012_11_M15_11_d N012_11 N012_11_M15_11_d 0.01
R_A_11_M15_11_g A_11 A_11_M15_11_g 0.01
M15_11 N012_11_M15_11_d A_11_M15_11_g 0 0 nmos l=1u w=8u
R_N010_11_M16_11_d N010_11 N010_11_M16_11_d 0.01
R_C_11_M16_11_g C_11 C_11_M16_11_g 0.01
M16_11 N010_11_M16_11_d C_11_M16_11_g 0 0 nmos l=1u w=2u
R_N010_11_M17_11_d N010_11 N010_11_M17_11_d 0.01
R_B_11_M17_11_g B_11 B_11_M17_11_g 0.01
M17_11 N010_11_M17_11_d B_11_M17_11_g 0 0 nmos l=1u w=2u
R_N010_11_M18_11_d N010_11 N010_11_M18_11_d 0.01
R_A_11_M18_11_g A_11 A_11_M18_11_g 0.01
M18_11 N010_11_M18_11_d A_11_M18_11_g 0 0 nmos l=1u w=2u
R_N007_11_M19_11_d N007_11 N007_11_M19_11_d 0.01
R_N005_11_M19_11_g N005_11 N005_11_M19_11_g 0.01
R_N010_11_M19_11_s N010_11 N010_11_M19_11_s 0.01
M19_11 N007_11_M19_11_d N005_11_M19_11_g N010_11_M19_11_s 0 nmos l=1u w=2u
R_N009_11_M20_11_d N009_11 N009_11_M20_11_d 0.01
R_B_11_M20_11_g B_11 B_11_M20_11_g 0.01
M20_11 N009_11_M20_11_d B_11_M20_11_g 0 0 nmos l=1u w=2u
R_N009_11_M21_11_d N009_11 N009_11_M21_11_d 0.01
R_A_11_M21_11_g A_11 A_11_M21_11_g 0.01
M21_11 N009_11_M21_11_d A_11_M21_11_g 0 0 nmos l=1u w=2u
R_N011_11_M22_11_d N011_11 N011_11_M22_11_d 0.01
R_A_11_M22_11_g A_11 A_11_M22_11_g 0.01
M22_11 N011_11_M22_11_d A_11_M22_11_g 0 0 nmos l=1u w=2u
R_N005_11_M23_11_d N005_11 N005_11_M23_11_d 0.01
R_B_11_M23_11_g B_11 B_11_M23_11_g 0.01
R_N011_11_M23_11_s N011_11 N011_11_M23_11_s 0.01
M23_11 N005_11_M23_11_d B_11_M23_11_g N011_11_M23_11_s 0 nmos l=1u w=2u
R_N005_11_M24_11_d N005_11 N005_11_M24_11_d 0.01
R_C_11_M24_11_g C_11 C_11_M24_11_g 0.01
R_N009_11_M24_11_s N009_11 N009_11_M24_11_s 0.01
M24_11 N005_11_M24_11_d C_11_M24_11_g N009_11_M24_11_s 0 nmos l=1u w=2u
R_C_12_M25_11_d C_12 C_12_M25_11_d 0.01
R_N005_11_M25_11_g N005_11 N005_11_M25_11_g 0.01
M25_11 C_12_M25_11_d N005_11_M25_11_g 0 0 nmos l=1u w=1u
R_N002_11_M26_11_d N002_11 N002_11_M26_11_d 0.01
R_N005_11_M26_11_g N005_11 N005_11_M26_11_g 0.01
R_N007_11_M26_11_s N007_11 N007_11_M26_11_s 0.01
R_VDD_M26_11_b VDD VDD_M26_11_b 0.01
M26_11 N002_11_M26_11_d N005_11_M26_11_g N007_11_M26_11_s VDD_M26_11_b pmos l=1u w=4u
R_VDD_M27_11_d VDD VDD_M27_11_d 0.01
R_N007_11_M27_11_g N007_11 N007_11_M27_11_g 0.01
R_S_11_M27_11_s S_11 S_11_M27_11_s 0.01
R_VDD_M27_11_b VDD VDD_M27_11_b 0.01
M27_11 VDD_M27_11_d N007_11_M27_11_g S_11_M27_11_s VDD_M27_11_b pmos l=1u w=2u
R_S_11_M28_11_d S_11 S_11_M28_11_d 0.01
R_N007_11_M28_11_g N007_11 N007_11_M28_11_g 0.01
M28_11 S_11_M28_11_d N007_11_M28_11_g 0 0 nmos l=1u w=1u
C_S_11 S_11 0 1f
* --- Bit 12 ---
R_VDD_M1_12_d VDD VDD_M1_12_d 0.01
R_A_12_M1_12_g A_12 A_12_M1_12_g 0.01
R_N003_12_M1_12_s N003_12 N003_12_M1_12_s 0.01
R_VDD_M1_12_b VDD VDD_M1_12_b 0.01
M1_12 VDD_M1_12_d A_12_M1_12_g N003_12_M1_12_s VDD_M1_12_b pmos l=1u w=4u
R_N003_12_M2_12_d N003_12 N003_12_M2_12_d 0.01
R_B_12_M2_12_g B_12 B_12_M2_12_g 0.01
R_N005_12_M2_12_s N005_12 N005_12_M2_12_s 0.01
R_VDD_M2_12_b VDD VDD_M2_12_b 0.01
M2_12 N003_12_M2_12_d B_12_M2_12_g N005_12_M2_12_s VDD_M2_12_b pmos l=1u w=4u
R_VDD_M3_12_d VDD VDD_M3_12_d 0.01
R_A_12_M3_12_g A_12 A_12_M3_12_g 0.01
R_N001_12_M3_12_s N001_12 N001_12_M3_12_s 0.01
R_VDD_M3_12_b VDD VDD_M3_12_b 0.01
M3_12 VDD_M3_12_d A_12_M3_12_g N001_12_M3_12_s VDD_M3_12_b pmos l=1u w=4u
R_N001_12_M4_12_d N001_12 N001_12_M4_12_d 0.01
R_C_12_M4_12_g C_12 C_12_M4_12_g 0.01
R_N005_12_M4_12_s N005_12 N005_12_M4_12_s 0.01
R_VDD_M4_12_b VDD VDD_M4_12_b 0.01
M4_12 N001_12_M4_12_d C_12_M4_12_g N005_12_M4_12_s VDD_M4_12_b pmos l=1u w=4u
R_VDD_M5_12_d VDD VDD_M5_12_d 0.01
R_B_12_M5_12_g B_12 B_12_M5_12_g 0.01
R_N001_12_M5_12_s N001_12 N001_12_M5_12_s 0.01
R_VDD_M5_12_b VDD VDD_M5_12_b 0.01
M5_12 VDD_M5_12_d B_12_M5_12_g N001_12_M5_12_s VDD_M5_12_b pmos l=1u w=4u
R_VDD_M6_12_d VDD VDD_M6_12_d 0.01
R_N005_12_M6_12_g N005_12 N005_12_M6_12_g 0.01
R_C_13_M6_12_s C_13 C_13_M6_12_s 0.01
R_VDD_M6_12_b VDD VDD_M6_12_b 0.01
M6_12 VDD_M6_12_d N005_12_M6_12_g C_13_M6_12_s VDD_M6_12_b pmos l=1u w=2u
R_VDD_M7_12_d VDD VDD_M7_12_d 0.01
R_A_12_M7_12_g A_12 A_12_M7_12_g 0.01
R_N002_12_M7_12_s N002_12 N002_12_M7_12_s 0.01
R_VDD_M7_12_b VDD VDD_M7_12_b 0.01
M7_12 VDD_M7_12_d A_12_M7_12_g N002_12_M7_12_s VDD_M7_12_b pmos l=1u w=4u
R_VDD_M8_12_d VDD VDD_M8_12_d 0.01
R_B_12_M8_12_g B_12 B_12_M8_12_g 0.01
R_N002_12_M8_12_s N002_12 N002_12_M8_12_s 0.01
R_VDD_M8_12_b VDD VDD_M8_12_b 0.01
M8_12 VDD_M8_12_d B_12_M8_12_g N002_12_M8_12_s VDD_M8_12_b pmos l=1u w=4u
R_VDD_M9_12_d VDD VDD_M9_12_d 0.01
R_C_12_M9_12_g C_12 C_12_M9_12_g 0.01
R_N002_12_M9_12_s N002_12 N002_12_M9_12_s 0.01
R_VDD_M9_12_b VDD VDD_M9_12_b 0.01
M9_12 VDD_M9_12_d C_12_M9_12_g N002_12_M9_12_s VDD_M9_12_b pmos l=1u w=4u
R_VDD_M10_12_d VDD VDD_M10_12_d 0.01
R_A_12_M10_12_g A_12 A_12_M10_12_g 0.01
R_N004_12_M10_12_s N004_12 N004_12_M10_12_s 0.01
R_VDD_M10_12_b VDD VDD_M10_12_b 0.01
M10_12 VDD_M10_12_d A_12_M10_12_g N004_12_M10_12_s VDD_M10_12_b pmos l=1u w=8u
R_N004_12_M11_12_d N004_12 N004_12_M11_12_d 0.01
R_B_12_M11_12_g B_12 B_12_M11_12_g 0.01
R_N006_12_M11_12_s N006_12 N006_12_M11_12_s 0.01
R_VDD_M11_12_b VDD VDD_M11_12_b 0.01
M11_12 N004_12_M11_12_d B_12_M11_12_g N006_12_M11_12_s VDD_M11_12_b pmos l=1u w=8u
R_N006_12_M12_12_d N006_12 N006_12_M12_12_d 0.01
R_C_12_M12_12_g C_12 C_12_M12_12_g 0.01
R_N007_12_M12_12_s N007_12 N007_12_M12_12_s 0.01
R_VDD_M12_12_b VDD VDD_M12_12_b 0.01
M12_12 N006_12_M12_12_d C_12_M12_12_g N007_12_M12_12_s VDD_M12_12_b pmos l=1u w=8u
R_N007_12_M13_12_d N007_12 N007_12_M13_12_d 0.01
R_C_12_M13_12_g C_12 C_12_M13_12_g 0.01
R_N008_12_M13_12_s N008_12 N008_12_M13_12_s 0.01
M13_12 N007_12_M13_12_d C_12_M13_12_g N008_12_M13_12_s 0 nmos l=1u w=8u
R_N008_12_M14_12_d N008_12 N008_12_M14_12_d 0.01
R_B_12_M14_12_g B_12 B_12_M14_12_g 0.01
R_N012_12_M14_12_s N012_12 N012_12_M14_12_s 0.01
M14_12 N008_12_M14_12_d B_12_M14_12_g N012_12_M14_12_s 0 nmos l=1u w=8u
R_N012_12_M15_12_d N012_12 N012_12_M15_12_d 0.01
R_A_12_M15_12_g A_12 A_12_M15_12_g 0.01
M15_12 N012_12_M15_12_d A_12_M15_12_g 0 0 nmos l=1u w=8u
R_N010_12_M16_12_d N010_12 N010_12_M16_12_d 0.01
R_C_12_M16_12_g C_12 C_12_M16_12_g 0.01
M16_12 N010_12_M16_12_d C_12_M16_12_g 0 0 nmos l=1u w=2u
R_N010_12_M17_12_d N010_12 N010_12_M17_12_d 0.01
R_B_12_M17_12_g B_12 B_12_M17_12_g 0.01
M17_12 N010_12_M17_12_d B_12_M17_12_g 0 0 nmos l=1u w=2u
R_N010_12_M18_12_d N010_12 N010_12_M18_12_d 0.01
R_A_12_M18_12_g A_12 A_12_M18_12_g 0.01
M18_12 N010_12_M18_12_d A_12_M18_12_g 0 0 nmos l=1u w=2u
R_N007_12_M19_12_d N007_12 N007_12_M19_12_d 0.01
R_N005_12_M19_12_g N005_12 N005_12_M19_12_g 0.01
R_N010_12_M19_12_s N010_12 N010_12_M19_12_s 0.01
M19_12 N007_12_M19_12_d N005_12_M19_12_g N010_12_M19_12_s 0 nmos l=1u w=2u
R_N009_12_M20_12_d N009_12 N009_12_M20_12_d 0.01
R_B_12_M20_12_g B_12 B_12_M20_12_g 0.01
M20_12 N009_12_M20_12_d B_12_M20_12_g 0 0 nmos l=1u w=2u
R_N009_12_M21_12_d N009_12 N009_12_M21_12_d 0.01
R_A_12_M21_12_g A_12 A_12_M21_12_g 0.01
M21_12 N009_12_M21_12_d A_12_M21_12_g 0 0 nmos l=1u w=2u
R_N011_12_M22_12_d N011_12 N011_12_M22_12_d 0.01
R_A_12_M22_12_g A_12 A_12_M22_12_g 0.01
M22_12 N011_12_M22_12_d A_12_M22_12_g 0 0 nmos l=1u w=2u
R_N005_12_M23_12_d N005_12 N005_12_M23_12_d 0.01
R_B_12_M23_12_g B_12 B_12_M23_12_g 0.01
R_N011_12_M23_12_s N011_12 N011_12_M23_12_s 0.01
M23_12 N005_12_M23_12_d B_12_M23_12_g N011_12_M23_12_s 0 nmos l=1u w=2u
R_N005_12_M24_12_d N005_12 N005_12_M24_12_d 0.01
R_C_12_M24_12_g C_12 C_12_M24_12_g 0.01
R_N009_12_M24_12_s N009_12 N009_12_M24_12_s 0.01
M24_12 N005_12_M24_12_d C_12_M24_12_g N009_12_M24_12_s 0 nmos l=1u w=2u
R_C_13_M25_12_d C_13 C_13_M25_12_d 0.01
R_N005_12_M25_12_g N005_12 N005_12_M25_12_g 0.01
M25_12 C_13_M25_12_d N005_12_M25_12_g 0 0 nmos l=1u w=1u
R_N002_12_M26_12_d N002_12 N002_12_M26_12_d 0.01
R_N005_12_M26_12_g N005_12 N005_12_M26_12_g 0.01
R_N007_12_M26_12_s N007_12 N007_12_M26_12_s 0.01
R_VDD_M26_12_b VDD VDD_M26_12_b 0.01
M26_12 N002_12_M26_12_d N005_12_M26_12_g N007_12_M26_12_s VDD_M26_12_b pmos l=1u w=4u
R_VDD_M27_12_d VDD VDD_M27_12_d 0.01
R_N007_12_M27_12_g N007_12 N007_12_M27_12_g 0.01
R_S_12_M27_12_s S_12 S_12_M27_12_s 0.01
R_VDD_M27_12_b VDD VDD_M27_12_b 0.01
M27_12 VDD_M27_12_d N007_12_M27_12_g S_12_M27_12_s VDD_M27_12_b pmos l=1u w=2u
R_S_12_M28_12_d S_12 S_12_M28_12_d 0.01
R_N007_12_M28_12_g N007_12 N007_12_M28_12_g 0.01
M28_12 S_12_M28_12_d N007_12_M28_12_g 0 0 nmos l=1u w=1u
C_S_12 S_12 0 1f
* --- Bit 13 ---
R_VDD_M1_13_d VDD VDD_M1_13_d 0.01
R_A_13_M1_13_g A_13 A_13_M1_13_g 0.01
R_N003_13_M1_13_s N003_13 N003_13_M1_13_s 0.01
R_VDD_M1_13_b VDD VDD_M1_13_b 0.01
M1_13 VDD_M1_13_d A_13_M1_13_g N003_13_M1_13_s VDD_M1_13_b pmos l=1u w=4u
R_N003_13_M2_13_d N003_13 N003_13_M2_13_d 0.01
R_B_13_M2_13_g B_13 B_13_M2_13_g 0.01
R_N005_13_M2_13_s N005_13 N005_13_M2_13_s 0.01
R_VDD_M2_13_b VDD VDD_M2_13_b 0.01
M2_13 N003_13_M2_13_d B_13_M2_13_g N005_13_M2_13_s VDD_M2_13_b pmos l=1u w=4u
R_VDD_M3_13_d VDD VDD_M3_13_d 0.01
R_A_13_M3_13_g A_13 A_13_M3_13_g 0.01
R_N001_13_M3_13_s N001_13 N001_13_M3_13_s 0.01
R_VDD_M3_13_b VDD VDD_M3_13_b 0.01
M3_13 VDD_M3_13_d A_13_M3_13_g N001_13_M3_13_s VDD_M3_13_b pmos l=1u w=4u
R_N001_13_M4_13_d N001_13 N001_13_M4_13_d 0.01
R_C_13_M4_13_g C_13 C_13_M4_13_g 0.01
R_N005_13_M4_13_s N005_13 N005_13_M4_13_s 0.01
R_VDD_M4_13_b VDD VDD_M4_13_b 0.01
M4_13 N001_13_M4_13_d C_13_M4_13_g N005_13_M4_13_s VDD_M4_13_b pmos l=1u w=4u
R_VDD_M5_13_d VDD VDD_M5_13_d 0.01
R_B_13_M5_13_g B_13 B_13_M5_13_g 0.01
R_N001_13_M5_13_s N001_13 N001_13_M5_13_s 0.01
R_VDD_M5_13_b VDD VDD_M5_13_b 0.01
M5_13 VDD_M5_13_d B_13_M5_13_g N001_13_M5_13_s VDD_M5_13_b pmos l=1u w=4u
R_VDD_M6_13_d VDD VDD_M6_13_d 0.01
R_N005_13_M6_13_g N005_13 N005_13_M6_13_g 0.01
R_C_14_M6_13_s C_14 C_14_M6_13_s 0.01
R_VDD_M6_13_b VDD VDD_M6_13_b 0.01
M6_13 VDD_M6_13_d N005_13_M6_13_g C_14_M6_13_s VDD_M6_13_b pmos l=1u w=2u
R_VDD_M7_13_d VDD VDD_M7_13_d 0.01
R_A_13_M7_13_g A_13 A_13_M7_13_g 0.01
R_N002_13_M7_13_s N002_13 N002_13_M7_13_s 0.01
R_VDD_M7_13_b VDD VDD_M7_13_b 0.01
M7_13 VDD_M7_13_d A_13_M7_13_g N002_13_M7_13_s VDD_M7_13_b pmos l=1u w=4u
R_VDD_M8_13_d VDD VDD_M8_13_d 0.01
R_B_13_M8_13_g B_13 B_13_M8_13_g 0.01
R_N002_13_M8_13_s N002_13 N002_13_M8_13_s 0.01
R_VDD_M8_13_b VDD VDD_M8_13_b 0.01
M8_13 VDD_M8_13_d B_13_M8_13_g N002_13_M8_13_s VDD_M8_13_b pmos l=1u w=4u
R_VDD_M9_13_d VDD VDD_M9_13_d 0.01
R_C_13_M9_13_g C_13 C_13_M9_13_g 0.01
R_N002_13_M9_13_s N002_13 N002_13_M9_13_s 0.01
R_VDD_M9_13_b VDD VDD_M9_13_b 0.01
M9_13 VDD_M9_13_d C_13_M9_13_g N002_13_M9_13_s VDD_M9_13_b pmos l=1u w=4u
R_VDD_M10_13_d VDD VDD_M10_13_d 0.01
R_A_13_M10_13_g A_13 A_13_M10_13_g 0.01
R_N004_13_M10_13_s N004_13 N004_13_M10_13_s 0.01
R_VDD_M10_13_b VDD VDD_M10_13_b 0.01
M10_13 VDD_M10_13_d A_13_M10_13_g N004_13_M10_13_s VDD_M10_13_b pmos l=1u w=8u
R_N004_13_M11_13_d N004_13 N004_13_M11_13_d 0.01
R_B_13_M11_13_g B_13 B_13_M11_13_g 0.01
R_N006_13_M11_13_s N006_13 N006_13_M11_13_s 0.01
R_VDD_M11_13_b VDD VDD_M11_13_b 0.01
M11_13 N004_13_M11_13_d B_13_M11_13_g N006_13_M11_13_s VDD_M11_13_b pmos l=1u w=8u
R_N006_13_M12_13_d N006_13 N006_13_M12_13_d 0.01
R_C_13_M12_13_g C_13 C_13_M12_13_g 0.01
R_N007_13_M12_13_s N007_13 N007_13_M12_13_s 0.01
R_VDD_M12_13_b VDD VDD_M12_13_b 0.01
M12_13 N006_13_M12_13_d C_13_M12_13_g N007_13_M12_13_s VDD_M12_13_b pmos l=1u w=8u
R_N007_13_M13_13_d N007_13 N007_13_M13_13_d 0.01
R_C_13_M13_13_g C_13 C_13_M13_13_g 0.01
R_N008_13_M13_13_s N008_13 N008_13_M13_13_s 0.01
M13_13 N007_13_M13_13_d C_13_M13_13_g N008_13_M13_13_s 0 nmos l=1u w=8u
R_N008_13_M14_13_d N008_13 N008_13_M14_13_d 0.01
R_B_13_M14_13_g B_13 B_13_M14_13_g 0.01
R_N012_13_M14_13_s N012_13 N012_13_M14_13_s 0.01
M14_13 N008_13_M14_13_d B_13_M14_13_g N012_13_M14_13_s 0 nmos l=1u w=8u
R_N012_13_M15_13_d N012_13 N012_13_M15_13_d 0.01
R_A_13_M15_13_g A_13 A_13_M15_13_g 0.01
M15_13 N012_13_M15_13_d A_13_M15_13_g 0 0 nmos l=1u w=8u
R_N010_13_M16_13_d N010_13 N010_13_M16_13_d 0.01
R_C_13_M16_13_g C_13 C_13_M16_13_g 0.01
M16_13 N010_13_M16_13_d C_13_M16_13_g 0 0 nmos l=1u w=2u
R_N010_13_M17_13_d N010_13 N010_13_M17_13_d 0.01
R_B_13_M17_13_g B_13 B_13_M17_13_g 0.01
M17_13 N010_13_M17_13_d B_13_M17_13_g 0 0 nmos l=1u w=2u
R_N010_13_M18_13_d N010_13 N010_13_M18_13_d 0.01
R_A_13_M18_13_g A_13 A_13_M18_13_g 0.01
M18_13 N010_13_M18_13_d A_13_M18_13_g 0 0 nmos l=1u w=2u
R_N007_13_M19_13_d N007_13 N007_13_M19_13_d 0.01
R_N005_13_M19_13_g N005_13 N005_13_M19_13_g 0.01
R_N010_13_M19_13_s N010_13 N010_13_M19_13_s 0.01
M19_13 N007_13_M19_13_d N005_13_M19_13_g N010_13_M19_13_s 0 nmos l=1u w=2u
R_N009_13_M20_13_d N009_13 N009_13_M20_13_d 0.01
R_B_13_M20_13_g B_13 B_13_M20_13_g 0.01
M20_13 N009_13_M20_13_d B_13_M20_13_g 0 0 nmos l=1u w=2u
R_N009_13_M21_13_d N009_13 N009_13_M21_13_d 0.01
R_A_13_M21_13_g A_13 A_13_M21_13_g 0.01
M21_13 N009_13_M21_13_d A_13_M21_13_g 0 0 nmos l=1u w=2u
R_N011_13_M22_13_d N011_13 N011_13_M22_13_d 0.01
R_A_13_M22_13_g A_13 A_13_M22_13_g 0.01
M22_13 N011_13_M22_13_d A_13_M22_13_g 0 0 nmos l=1u w=2u
R_N005_13_M23_13_d N005_13 N005_13_M23_13_d 0.01
R_B_13_M23_13_g B_13 B_13_M23_13_g 0.01
R_N011_13_M23_13_s N011_13 N011_13_M23_13_s 0.01
M23_13 N005_13_M23_13_d B_13_M23_13_g N011_13_M23_13_s 0 nmos l=1u w=2u
R_N005_13_M24_13_d N005_13 N005_13_M24_13_d 0.01
R_C_13_M24_13_g C_13 C_13_M24_13_g 0.01
R_N009_13_M24_13_s N009_13 N009_13_M24_13_s 0.01
M24_13 N005_13_M24_13_d C_13_M24_13_g N009_13_M24_13_s 0 nmos l=1u w=2u
R_C_14_M25_13_d C_14 C_14_M25_13_d 0.01
R_N005_13_M25_13_g N005_13 N005_13_M25_13_g 0.01
M25_13 C_14_M25_13_d N005_13_M25_13_g 0 0 nmos l=1u w=1u
R_N002_13_M26_13_d N002_13 N002_13_M26_13_d 0.01
R_N005_13_M26_13_g N005_13 N005_13_M26_13_g 0.01
R_N007_13_M26_13_s N007_13 N007_13_M26_13_s 0.01
R_VDD_M26_13_b VDD VDD_M26_13_b 0.01
M26_13 N002_13_M26_13_d N005_13_M26_13_g N007_13_M26_13_s VDD_M26_13_b pmos l=1u w=4u
R_VDD_M27_13_d VDD VDD_M27_13_d 0.01
R_N007_13_M27_13_g N007_13 N007_13_M27_13_g 0.01
R_S_13_M27_13_s S_13 S_13_M27_13_s 0.01
R_VDD_M27_13_b VDD VDD_M27_13_b 0.01
M27_13 VDD_M27_13_d N007_13_M27_13_g S_13_M27_13_s VDD_M27_13_b pmos l=1u w=2u
R_S_13_M28_13_d S_13 S_13_M28_13_d 0.01
R_N007_13_M28_13_g N007_13 N007_13_M28_13_g 0.01
M28_13 S_13_M28_13_d N007_13_M28_13_g 0 0 nmos l=1u w=1u
C_S_13 S_13 0 1f
* --- Bit 14 ---
R_VDD_M1_14_d VDD VDD_M1_14_d 0.01
R_A_14_M1_14_g A_14 A_14_M1_14_g 0.01
R_N003_14_M1_14_s N003_14 N003_14_M1_14_s 0.01
R_VDD_M1_14_b VDD VDD_M1_14_b 0.01
M1_14 VDD_M1_14_d A_14_M1_14_g N003_14_M1_14_s VDD_M1_14_b pmos l=1u w=4u
R_N003_14_M2_14_d N003_14 N003_14_M2_14_d 0.01
R_B_14_M2_14_g B_14 B_14_M2_14_g 0.01
R_N005_14_M2_14_s N005_14 N005_14_M2_14_s 0.01
R_VDD_M2_14_b VDD VDD_M2_14_b 0.01
M2_14 N003_14_M2_14_d B_14_M2_14_g N005_14_M2_14_s VDD_M2_14_b pmos l=1u w=4u
R_VDD_M3_14_d VDD VDD_M3_14_d 0.01
R_A_14_M3_14_g A_14 A_14_M3_14_g 0.01
R_N001_14_M3_14_s N001_14 N001_14_M3_14_s 0.01
R_VDD_M3_14_b VDD VDD_M3_14_b 0.01
M3_14 VDD_M3_14_d A_14_M3_14_g N001_14_M3_14_s VDD_M3_14_b pmos l=1u w=4u
R_N001_14_M4_14_d N001_14 N001_14_M4_14_d 0.01
R_C_14_M4_14_g C_14 C_14_M4_14_g 0.01
R_N005_14_M4_14_s N005_14 N005_14_M4_14_s 0.01
R_VDD_M4_14_b VDD VDD_M4_14_b 0.01
M4_14 N001_14_M4_14_d C_14_M4_14_g N005_14_M4_14_s VDD_M4_14_b pmos l=1u w=4u
R_VDD_M5_14_d VDD VDD_M5_14_d 0.01
R_B_14_M5_14_g B_14 B_14_M5_14_g 0.01
R_N001_14_M5_14_s N001_14 N001_14_M5_14_s 0.01
R_VDD_M5_14_b VDD VDD_M5_14_b 0.01
M5_14 VDD_M5_14_d B_14_M5_14_g N001_14_M5_14_s VDD_M5_14_b pmos l=1u w=4u
R_VDD_M6_14_d VDD VDD_M6_14_d 0.01
R_N005_14_M6_14_g N005_14 N005_14_M6_14_g 0.01
R_C_15_M6_14_s C_15 C_15_M6_14_s 0.01
R_VDD_M6_14_b VDD VDD_M6_14_b 0.01
M6_14 VDD_M6_14_d N005_14_M6_14_g C_15_M6_14_s VDD_M6_14_b pmos l=1u w=2u
R_VDD_M7_14_d VDD VDD_M7_14_d 0.01
R_A_14_M7_14_g A_14 A_14_M7_14_g 0.01
R_N002_14_M7_14_s N002_14 N002_14_M7_14_s 0.01
R_VDD_M7_14_b VDD VDD_M7_14_b 0.01
M7_14 VDD_M7_14_d A_14_M7_14_g N002_14_M7_14_s VDD_M7_14_b pmos l=1u w=4u
R_VDD_M8_14_d VDD VDD_M8_14_d 0.01
R_B_14_M8_14_g B_14 B_14_M8_14_g 0.01
R_N002_14_M8_14_s N002_14 N002_14_M8_14_s 0.01
R_VDD_M8_14_b VDD VDD_M8_14_b 0.01
M8_14 VDD_M8_14_d B_14_M8_14_g N002_14_M8_14_s VDD_M8_14_b pmos l=1u w=4u
R_VDD_M9_14_d VDD VDD_M9_14_d 0.01
R_C_14_M9_14_g C_14 C_14_M9_14_g 0.01
R_N002_14_M9_14_s N002_14 N002_14_M9_14_s 0.01
R_VDD_M9_14_b VDD VDD_M9_14_b 0.01
M9_14 VDD_M9_14_d C_14_M9_14_g N002_14_M9_14_s VDD_M9_14_b pmos l=1u w=4u
R_VDD_M10_14_d VDD VDD_M10_14_d 0.01
R_A_14_M10_14_g A_14 A_14_M10_14_g 0.01
R_N004_14_M10_14_s N004_14 N004_14_M10_14_s 0.01
R_VDD_M10_14_b VDD VDD_M10_14_b 0.01
M10_14 VDD_M10_14_d A_14_M10_14_g N004_14_M10_14_s VDD_M10_14_b pmos l=1u w=8u
R_N004_14_M11_14_d N004_14 N004_14_M11_14_d 0.01
R_B_14_M11_14_g B_14 B_14_M11_14_g 0.01
R_N006_14_M11_14_s N006_14 N006_14_M11_14_s 0.01
R_VDD_M11_14_b VDD VDD_M11_14_b 0.01
M11_14 N004_14_M11_14_d B_14_M11_14_g N006_14_M11_14_s VDD_M11_14_b pmos l=1u w=8u
R_N006_14_M12_14_d N006_14 N006_14_M12_14_d 0.01
R_C_14_M12_14_g C_14 C_14_M12_14_g 0.01
R_N007_14_M12_14_s N007_14 N007_14_M12_14_s 0.01
R_VDD_M12_14_b VDD VDD_M12_14_b 0.01
M12_14 N006_14_M12_14_d C_14_M12_14_g N007_14_M12_14_s VDD_M12_14_b pmos l=1u w=8u
R_N007_14_M13_14_d N007_14 N007_14_M13_14_d 0.01
R_C_14_M13_14_g C_14 C_14_M13_14_g 0.01
R_N008_14_M13_14_s N008_14 N008_14_M13_14_s 0.01
M13_14 N007_14_M13_14_d C_14_M13_14_g N008_14_M13_14_s 0 nmos l=1u w=8u
R_N008_14_M14_14_d N008_14 N008_14_M14_14_d 0.01
R_B_14_M14_14_g B_14 B_14_M14_14_g 0.01
R_N012_14_M14_14_s N012_14 N012_14_M14_14_s 0.01
M14_14 N008_14_M14_14_d B_14_M14_14_g N012_14_M14_14_s 0 nmos l=1u w=8u
R_N012_14_M15_14_d N012_14 N012_14_M15_14_d 0.01
R_A_14_M15_14_g A_14 A_14_M15_14_g 0.01
M15_14 N012_14_M15_14_d A_14_M15_14_g 0 0 nmos l=1u w=8u
R_N010_14_M16_14_d N010_14 N010_14_M16_14_d 0.01
R_C_14_M16_14_g C_14 C_14_M16_14_g 0.01
M16_14 N010_14_M16_14_d C_14_M16_14_g 0 0 nmos l=1u w=2u
R_N010_14_M17_14_d N010_14 N010_14_M17_14_d 0.01
R_B_14_M17_14_g B_14 B_14_M17_14_g 0.01
M17_14 N010_14_M17_14_d B_14_M17_14_g 0 0 nmos l=1u w=2u
R_N010_14_M18_14_d N010_14 N010_14_M18_14_d 0.01
R_A_14_M18_14_g A_14 A_14_M18_14_g 0.01
M18_14 N010_14_M18_14_d A_14_M18_14_g 0 0 nmos l=1u w=2u
R_N007_14_M19_14_d N007_14 N007_14_M19_14_d 0.01
R_N005_14_M19_14_g N005_14 N005_14_M19_14_g 0.01
R_N010_14_M19_14_s N010_14 N010_14_M19_14_s 0.01
M19_14 N007_14_M19_14_d N005_14_M19_14_g N010_14_M19_14_s 0 nmos l=1u w=2u
R_N009_14_M20_14_d N009_14 N009_14_M20_14_d 0.01
R_B_14_M20_14_g B_14 B_14_M20_14_g 0.01
M20_14 N009_14_M20_14_d B_14_M20_14_g 0 0 nmos l=1u w=2u
R_N009_14_M21_14_d N009_14 N009_14_M21_14_d 0.01
R_A_14_M21_14_g A_14 A_14_M21_14_g 0.01
M21_14 N009_14_M21_14_d A_14_M21_14_g 0 0 nmos l=1u w=2u
R_N011_14_M22_14_d N011_14 N011_14_M22_14_d 0.01
R_A_14_M22_14_g A_14 A_14_M22_14_g 0.01
M22_14 N011_14_M22_14_d A_14_M22_14_g 0 0 nmos l=1u w=2u
R_N005_14_M23_14_d N005_14 N005_14_M23_14_d 0.01
R_B_14_M23_14_g B_14 B_14_M23_14_g 0.01
R_N011_14_M23_14_s N011_14 N011_14_M23_14_s 0.01
M23_14 N005_14_M23_14_d B_14_M23_14_g N011_14_M23_14_s 0 nmos l=1u w=2u
R_N005_14_M24_14_d N005_14 N005_14_M24_14_d 0.01
R_C_14_M24_14_g C_14 C_14_M24_14_g 0.01
R_N009_14_M24_14_s N009_14 N009_14_M24_14_s 0.01
M24_14 N005_14_M24_14_d C_14_M24_14_g N009_14_M24_14_s 0 nmos l=1u w=2u
R_C_15_M25_14_d C_15 C_15_M25_14_d 0.01
R_N005_14_M25_14_g N005_14 N005_14_M25_14_g 0.01
M25_14 C_15_M25_14_d N005_14_M25_14_g 0 0 nmos l=1u w=1u
R_N002_14_M26_14_d N002_14 N002_14_M26_14_d 0.01
R_N005_14_M26_14_g N005_14 N005_14_M26_14_g 0.01
R_N007_14_M26_14_s N007_14 N007_14_M26_14_s 0.01
R_VDD_M26_14_b VDD VDD_M26_14_b 0.01
M26_14 N002_14_M26_14_d N005_14_M26_14_g N007_14_M26_14_s VDD_M26_14_b pmos l=1u w=4u
R_VDD_M27_14_d VDD VDD_M27_14_d 0.01
R_N007_14_M27_14_g N007_14 N007_14_M27_14_g 0.01
R_S_14_M27_14_s S_14 S_14_M27_14_s 0.01
R_VDD_M27_14_b VDD VDD_M27_14_b 0.01
M27_14 VDD_M27_14_d N007_14_M27_14_g S_14_M27_14_s VDD_M27_14_b pmos l=1u w=2u
R_S_14_M28_14_d S_14 S_14_M28_14_d 0.01
R_N007_14_M28_14_g N007_14 N007_14_M28_14_g 0.01
M28_14 S_14_M28_14_d N007_14_M28_14_g 0 0 nmos l=1u w=1u
C_S_14 S_14 0 1f
* --- Bit 15 ---
R_VDD_M1_15_d VDD VDD_M1_15_d 0.01
R_A_15_M1_15_g A_15 A_15_M1_15_g 0.01
R_N003_15_M1_15_s N003_15 N003_15_M1_15_s 0.01
R_VDD_M1_15_b VDD VDD_M1_15_b 0.01
M1_15 VDD_M1_15_d A_15_M1_15_g N003_15_M1_15_s VDD_M1_15_b pmos l=1u w=4u
R_N003_15_M2_15_d N003_15 N003_15_M2_15_d 0.01
R_B_15_M2_15_g B_15 B_15_M2_15_g 0.01
R_N005_15_M2_15_s N005_15 N005_15_M2_15_s 0.01
R_VDD_M2_15_b VDD VDD_M2_15_b 0.01
M2_15 N003_15_M2_15_d B_15_M2_15_g N005_15_M2_15_s VDD_M2_15_b pmos l=1u w=4u
R_VDD_M3_15_d VDD VDD_M3_15_d 0.01
R_A_15_M3_15_g A_15 A_15_M3_15_g 0.01
R_N001_15_M3_15_s N001_15 N001_15_M3_15_s 0.01
R_VDD_M3_15_b VDD VDD_M3_15_b 0.01
M3_15 VDD_M3_15_d A_15_M3_15_g N001_15_M3_15_s VDD_M3_15_b pmos l=1u w=4u
R_N001_15_M4_15_d N001_15 N001_15_M4_15_d 0.01
R_C_15_M4_15_g C_15 C_15_M4_15_g 0.01
R_N005_15_M4_15_s N005_15 N005_15_M4_15_s 0.01
R_VDD_M4_15_b VDD VDD_M4_15_b 0.01
M4_15 N001_15_M4_15_d C_15_M4_15_g N005_15_M4_15_s VDD_M4_15_b pmos l=1u w=4u
R_VDD_M5_15_d VDD VDD_M5_15_d 0.01
R_B_15_M5_15_g B_15 B_15_M5_15_g 0.01
R_N001_15_M5_15_s N001_15 N001_15_M5_15_s 0.01
R_VDD_M5_15_b VDD VDD_M5_15_b 0.01
M5_15 VDD_M5_15_d B_15_M5_15_g N001_15_M5_15_s VDD_M5_15_b pmos l=1u w=4u
R_VDD_M6_15_d VDD VDD_M6_15_d 0.01
R_N005_15_M6_15_g N005_15 N005_15_M6_15_g 0.01
R_C_16_M6_15_s C_16 C_16_M6_15_s 0.01
R_VDD_M6_15_b VDD VDD_M6_15_b 0.01
M6_15 VDD_M6_15_d N005_15_M6_15_g C_16_M6_15_s VDD_M6_15_b pmos l=1u w=2u
R_VDD_M7_15_d VDD VDD_M7_15_d 0.01
R_A_15_M7_15_g A_15 A_15_M7_15_g 0.01
R_N002_15_M7_15_s N002_15 N002_15_M7_15_s 0.01
R_VDD_M7_15_b VDD VDD_M7_15_b 0.01
M7_15 VDD_M7_15_d A_15_M7_15_g N002_15_M7_15_s VDD_M7_15_b pmos l=1u w=4u
R_VDD_M8_15_d VDD VDD_M8_15_d 0.01
R_B_15_M8_15_g B_15 B_15_M8_15_g 0.01
R_N002_15_M8_15_s N002_15 N002_15_M8_15_s 0.01
R_VDD_M8_15_b VDD VDD_M8_15_b 0.01
M8_15 VDD_M8_15_d B_15_M8_15_g N002_15_M8_15_s VDD_M8_15_b pmos l=1u w=4u
R_VDD_M9_15_d VDD VDD_M9_15_d 0.01
R_C_15_M9_15_g C_15 C_15_M9_15_g 0.01
R_N002_15_M9_15_s N002_15 N002_15_M9_15_s 0.01
R_VDD_M9_15_b VDD VDD_M9_15_b 0.01
M9_15 VDD_M9_15_d C_15_M9_15_g N002_15_M9_15_s VDD_M9_15_b pmos l=1u w=4u
R_VDD_M10_15_d VDD VDD_M10_15_d 0.01
R_A_15_M10_15_g A_15 A_15_M10_15_g 0.01
R_N004_15_M10_15_s N004_15 N004_15_M10_15_s 0.01
R_VDD_M10_15_b VDD VDD_M10_15_b 0.01
M10_15 VDD_M10_15_d A_15_M10_15_g N004_15_M10_15_s VDD_M10_15_b pmos l=1u w=8u
R_N004_15_M11_15_d N004_15 N004_15_M11_15_d 0.01
R_B_15_M11_15_g B_15 B_15_M11_15_g 0.01
R_N006_15_M11_15_s N006_15 N006_15_M11_15_s 0.01
R_VDD_M11_15_b VDD VDD_M11_15_b 0.01
M11_15 N004_15_M11_15_d B_15_M11_15_g N006_15_M11_15_s VDD_M11_15_b pmos l=1u w=8u
R_N006_15_M12_15_d N006_15 N006_15_M12_15_d 0.01
R_C_15_M12_15_g C_15 C_15_M12_15_g 0.01
R_N007_15_M12_15_s N007_15 N007_15_M12_15_s 0.01
R_VDD_M12_15_b VDD VDD_M12_15_b 0.01
M12_15 N006_15_M12_15_d C_15_M12_15_g N007_15_M12_15_s VDD_M12_15_b pmos l=1u w=8u
R_N007_15_M13_15_d N007_15 N007_15_M13_15_d 0.01
R_C_15_M13_15_g C_15 C_15_M13_15_g 0.01
R_N008_15_M13_15_s N008_15 N008_15_M13_15_s 0.01
M13_15 N007_15_M13_15_d C_15_M13_15_g N008_15_M13_15_s 0 nmos l=1u w=8u
R_N008_15_M14_15_d N008_15 N008_15_M14_15_d 0.01
R_B_15_M14_15_g B_15 B_15_M14_15_g 0.01
R_N012_15_M14_15_s N012_15 N012_15_M14_15_s 0.01
M14_15 N008_15_M14_15_d B_15_M14_15_g N012_15_M14_15_s 0 nmos l=1u w=8u
R_N012_15_M15_15_d N012_15 N012_15_M15_15_d 0.01
R_A_15_M15_15_g A_15 A_15_M15_15_g 0.01
M15_15 N012_15_M15_15_d A_15_M15_15_g 0 0 nmos l=1u w=8u
R_N010_15_M16_15_d N010_15 N010_15_M16_15_d 0.01
R_C_15_M16_15_g C_15 C_15_M16_15_g 0.01
M16_15 N010_15_M16_15_d C_15_M16_15_g 0 0 nmos l=1u w=2u
R_N010_15_M17_15_d N010_15 N010_15_M17_15_d 0.01
R_B_15_M17_15_g B_15 B_15_M17_15_g 0.01
M17_15 N010_15_M17_15_d B_15_M17_15_g 0 0 nmos l=1u w=2u
R_N010_15_M18_15_d N010_15 N010_15_M18_15_d 0.01
R_A_15_M18_15_g A_15 A_15_M18_15_g 0.01
M18_15 N010_15_M18_15_d A_15_M18_15_g 0 0 nmos l=1u w=2u
R_N007_15_M19_15_d N007_15 N007_15_M19_15_d 0.01
R_N005_15_M19_15_g N005_15 N005_15_M19_15_g 0.01
R_N010_15_M19_15_s N010_15 N010_15_M19_15_s 0.01
M19_15 N007_15_M19_15_d N005_15_M19_15_g N010_15_M19_15_s 0 nmos l=1u w=2u
R_N009_15_M20_15_d N009_15 N009_15_M20_15_d 0.01
R_B_15_M20_15_g B_15 B_15_M20_15_g 0.01
M20_15 N009_15_M20_15_d B_15_M20_15_g 0 0 nmos l=1u w=2u
R_N009_15_M21_15_d N009_15 N009_15_M21_15_d 0.01
R_A_15_M21_15_g A_15 A_15_M21_15_g 0.01
M21_15 N009_15_M21_15_d A_15_M21_15_g 0 0 nmos l=1u w=2u
R_N011_15_M22_15_d N011_15 N011_15_M22_15_d 0.01
R_A_15_M22_15_g A_15 A_15_M22_15_g 0.01
M22_15 N011_15_M22_15_d A_15_M22_15_g 0 0 nmos l=1u w=2u
R_N005_15_M23_15_d N005_15 N005_15_M23_15_d 0.01
R_B_15_M23_15_g B_15 B_15_M23_15_g 0.01
R_N011_15_M23_15_s N011_15 N011_15_M23_15_s 0.01
M23_15 N005_15_M23_15_d B_15_M23_15_g N011_15_M23_15_s 0 nmos l=1u w=2u
R_N005_15_M24_15_d N005_15 N005_15_M24_15_d 0.01
R_C_15_M24_15_g C_15 C_15_M24_15_g 0.01
R_N009_15_M24_15_s N009_15 N009_15_M24_15_s 0.01
M24_15 N005_15_M24_15_d C_15_M24_15_g N009_15_M24_15_s 0 nmos l=1u w=2u
R_C_16_M25_15_d C_16 C_16_M25_15_d 0.01
R_N005_15_M25_15_g N005_15 N005_15_M25_15_g 0.01
M25_15 C_16_M25_15_d N005_15_M25_15_g 0 0 nmos l=1u w=1u
R_N002_15_M26_15_d N002_15 N002_15_M26_15_d 0.01
R_N005_15_M26_15_g N005_15 N005_15_M26_15_g 0.01
R_N007_15_M26_15_s N007_15 N007_15_M26_15_s 0.01
R_VDD_M26_15_b VDD VDD_M26_15_b 0.01
M26_15 N002_15_M26_15_d N005_15_M26_15_g N007_15_M26_15_s VDD_M26_15_b pmos l=1u w=4u
R_VDD_M27_15_d VDD VDD_M27_15_d 0.01
R_N007_15_M27_15_g N007_15 N007_15_M27_15_g 0.01
R_S_15_M27_15_s S_15 S_15_M27_15_s 0.01
R_VDD_M27_15_b VDD VDD_M27_15_b 0.01
M27_15 VDD_M27_15_d N007_15_M27_15_g S_15_M27_15_s VDD_M27_15_b pmos l=1u w=2u
R_S_15_M28_15_d S_15 S_15_M28_15_d 0.01
R_N007_15_M28_15_g N007_15 N007_15_M28_15_g 0.01
M28_15 S_15_M28_15_d N007_15_M28_15_g 0 0 nmos l=1u w=1u
C_S_15 S_15 0 1f
* --- Bit 16 ---
R_VDD_M1_16_d VDD VDD_M1_16_d 0.01
R_A_16_M1_16_g A_16 A_16_M1_16_g 0.01
R_N003_16_M1_16_s N003_16 N003_16_M1_16_s 0.01
R_VDD_M1_16_b VDD VDD_M1_16_b 0.01
M1_16 VDD_M1_16_d A_16_M1_16_g N003_16_M1_16_s VDD_M1_16_b pmos l=1u w=4u
R_N003_16_M2_16_d N003_16 N003_16_M2_16_d 0.01
R_B_16_M2_16_g B_16 B_16_M2_16_g 0.01
R_N005_16_M2_16_s N005_16 N005_16_M2_16_s 0.01
R_VDD_M2_16_b VDD VDD_M2_16_b 0.01
M2_16 N003_16_M2_16_d B_16_M2_16_g N005_16_M2_16_s VDD_M2_16_b pmos l=1u w=4u
R_VDD_M3_16_d VDD VDD_M3_16_d 0.01
R_A_16_M3_16_g A_16 A_16_M3_16_g 0.01
R_N001_16_M3_16_s N001_16 N001_16_M3_16_s 0.01
R_VDD_M3_16_b VDD VDD_M3_16_b 0.01
M3_16 VDD_M3_16_d A_16_M3_16_g N001_16_M3_16_s VDD_M3_16_b pmos l=1u w=4u
R_N001_16_M4_16_d N001_16 N001_16_M4_16_d 0.01
R_C_16_M4_16_g C_16 C_16_M4_16_g 0.01
R_N005_16_M4_16_s N005_16 N005_16_M4_16_s 0.01
R_VDD_M4_16_b VDD VDD_M4_16_b 0.01
M4_16 N001_16_M4_16_d C_16_M4_16_g N005_16_M4_16_s VDD_M4_16_b pmos l=1u w=4u
R_VDD_M5_16_d VDD VDD_M5_16_d 0.01
R_B_16_M5_16_g B_16 B_16_M5_16_g 0.01
R_N001_16_M5_16_s N001_16 N001_16_M5_16_s 0.01
R_VDD_M5_16_b VDD VDD_M5_16_b 0.01
M5_16 VDD_M5_16_d B_16_M5_16_g N001_16_M5_16_s VDD_M5_16_b pmos l=1u w=4u
R_VDD_M6_16_d VDD VDD_M6_16_d 0.01
R_N005_16_M6_16_g N005_16 N005_16_M6_16_g 0.01
R_C_17_M6_16_s C_17 C_17_M6_16_s 0.01
R_VDD_M6_16_b VDD VDD_M6_16_b 0.01
M6_16 VDD_M6_16_d N005_16_M6_16_g C_17_M6_16_s VDD_M6_16_b pmos l=1u w=2u
R_VDD_M7_16_d VDD VDD_M7_16_d 0.01
R_A_16_M7_16_g A_16 A_16_M7_16_g 0.01
R_N002_16_M7_16_s N002_16 N002_16_M7_16_s 0.01
R_VDD_M7_16_b VDD VDD_M7_16_b 0.01
M7_16 VDD_M7_16_d A_16_M7_16_g N002_16_M7_16_s VDD_M7_16_b pmos l=1u w=4u
R_VDD_M8_16_d VDD VDD_M8_16_d 0.01
R_B_16_M8_16_g B_16 B_16_M8_16_g 0.01
R_N002_16_M8_16_s N002_16 N002_16_M8_16_s 0.01
R_VDD_M8_16_b VDD VDD_M8_16_b 0.01
M8_16 VDD_M8_16_d B_16_M8_16_g N002_16_M8_16_s VDD_M8_16_b pmos l=1u w=4u
R_VDD_M9_16_d VDD VDD_M9_16_d 0.01
R_C_16_M9_16_g C_16 C_16_M9_16_g 0.01
R_N002_16_M9_16_s N002_16 N002_16_M9_16_s 0.01
R_VDD_M9_16_b VDD VDD_M9_16_b 0.01
M9_16 VDD_M9_16_d C_16_M9_16_g N002_16_M9_16_s VDD_M9_16_b pmos l=1u w=4u
R_VDD_M10_16_d VDD VDD_M10_16_d 0.01
R_A_16_M10_16_g A_16 A_16_M10_16_g 0.01
R_N004_16_M10_16_s N004_16 N004_16_M10_16_s 0.01
R_VDD_M10_16_b VDD VDD_M10_16_b 0.01
M10_16 VDD_M10_16_d A_16_M10_16_g N004_16_M10_16_s VDD_M10_16_b pmos l=1u w=8u
R_N004_16_M11_16_d N004_16 N004_16_M11_16_d 0.01
R_B_16_M11_16_g B_16 B_16_M11_16_g 0.01
R_N006_16_M11_16_s N006_16 N006_16_M11_16_s 0.01
R_VDD_M11_16_b VDD VDD_M11_16_b 0.01
M11_16 N004_16_M11_16_d B_16_M11_16_g N006_16_M11_16_s VDD_M11_16_b pmos l=1u w=8u
R_N006_16_M12_16_d N006_16 N006_16_M12_16_d 0.01
R_C_16_M12_16_g C_16 C_16_M12_16_g 0.01
R_N007_16_M12_16_s N007_16 N007_16_M12_16_s 0.01
R_VDD_M12_16_b VDD VDD_M12_16_b 0.01
M12_16 N006_16_M12_16_d C_16_M12_16_g N007_16_M12_16_s VDD_M12_16_b pmos l=1u w=8u
R_N007_16_M13_16_d N007_16 N007_16_M13_16_d 0.01
R_C_16_M13_16_g C_16 C_16_M13_16_g 0.01
R_N008_16_M13_16_s N008_16 N008_16_M13_16_s 0.01
M13_16 N007_16_M13_16_d C_16_M13_16_g N008_16_M13_16_s 0 nmos l=1u w=8u
R_N008_16_M14_16_d N008_16 N008_16_M14_16_d 0.01
R_B_16_M14_16_g B_16 B_16_M14_16_g 0.01
R_N012_16_M14_16_s N012_16 N012_16_M14_16_s 0.01
M14_16 N008_16_M14_16_d B_16_M14_16_g N012_16_M14_16_s 0 nmos l=1u w=8u
R_N012_16_M15_16_d N012_16 N012_16_M15_16_d 0.01
R_A_16_M15_16_g A_16 A_16_M15_16_g 0.01
M15_16 N012_16_M15_16_d A_16_M15_16_g 0 0 nmos l=1u w=8u
R_N010_16_M16_16_d N010_16 N010_16_M16_16_d 0.01
R_C_16_M16_16_g C_16 C_16_M16_16_g 0.01
M16_16 N010_16_M16_16_d C_16_M16_16_g 0 0 nmos l=1u w=2u
R_N010_16_M17_16_d N010_16 N010_16_M17_16_d 0.01
R_B_16_M17_16_g B_16 B_16_M17_16_g 0.01
M17_16 N010_16_M17_16_d B_16_M17_16_g 0 0 nmos l=1u w=2u
R_N010_16_M18_16_d N010_16 N010_16_M18_16_d 0.01
R_A_16_M18_16_g A_16 A_16_M18_16_g 0.01
M18_16 N010_16_M18_16_d A_16_M18_16_g 0 0 nmos l=1u w=2u
R_N007_16_M19_16_d N007_16 N007_16_M19_16_d 0.01
R_N005_16_M19_16_g N005_16 N005_16_M19_16_g 0.01
R_N010_16_M19_16_s N010_16 N010_16_M19_16_s 0.01
M19_16 N007_16_M19_16_d N005_16_M19_16_g N010_16_M19_16_s 0 nmos l=1u w=2u
R_N009_16_M20_16_d N009_16 N009_16_M20_16_d 0.01
R_B_16_M20_16_g B_16 B_16_M20_16_g 0.01
M20_16 N009_16_M20_16_d B_16_M20_16_g 0 0 nmos l=1u w=2u
R_N009_16_M21_16_d N009_16 N009_16_M21_16_d 0.01
R_A_16_M21_16_g A_16 A_16_M21_16_g 0.01
M21_16 N009_16_M21_16_d A_16_M21_16_g 0 0 nmos l=1u w=2u
R_N011_16_M22_16_d N011_16 N011_16_M22_16_d 0.01
R_A_16_M22_16_g A_16 A_16_M22_16_g 0.01
M22_16 N011_16_M22_16_d A_16_M22_16_g 0 0 nmos l=1u w=2u
R_N005_16_M23_16_d N005_16 N005_16_M23_16_d 0.01
R_B_16_M23_16_g B_16 B_16_M23_16_g 0.01
R_N011_16_M23_16_s N011_16 N011_16_M23_16_s 0.01
M23_16 N005_16_M23_16_d B_16_M23_16_g N011_16_M23_16_s 0 nmos l=1u w=2u
R_N005_16_M24_16_d N005_16 N005_16_M24_16_d 0.01
R_C_16_M24_16_g C_16 C_16_M24_16_g 0.01
R_N009_16_M24_16_s N009_16 N009_16_M24_16_s 0.01
M24_16 N005_16_M24_16_d C_16_M24_16_g N009_16_M24_16_s 0 nmos l=1u w=2u
R_C_17_M25_16_d C_17 C_17_M25_16_d 0.01
R_N005_16_M25_16_g N005_16 N005_16_M25_16_g 0.01
M25_16 C_17_M25_16_d N005_16_M25_16_g 0 0 nmos l=1u w=1u
R_N002_16_M26_16_d N002_16 N002_16_M26_16_d 0.01
R_N005_16_M26_16_g N005_16 N005_16_M26_16_g 0.01
R_N007_16_M26_16_s N007_16 N007_16_M26_16_s 0.01
R_VDD_M26_16_b VDD VDD_M26_16_b 0.01
M26_16 N002_16_M26_16_d N005_16_M26_16_g N007_16_M26_16_s VDD_M26_16_b pmos l=1u w=4u
R_VDD_M27_16_d VDD VDD_M27_16_d 0.01
R_N007_16_M27_16_g N007_16 N007_16_M27_16_g 0.01
R_S_16_M27_16_s S_16 S_16_M27_16_s 0.01
R_VDD_M27_16_b VDD VDD_M27_16_b 0.01
M27_16 VDD_M27_16_d N007_16_M27_16_g S_16_M27_16_s VDD_M27_16_b pmos l=1u w=2u
R_S_16_M28_16_d S_16 S_16_M28_16_d 0.01
R_N007_16_M28_16_g N007_16 N007_16_M28_16_g 0.01
M28_16 S_16_M28_16_d N007_16_M28_16_g 0 0 nmos l=1u w=1u
C_S_16 S_16 0 1f
* --- Bit 17 ---
R_VDD_M1_17_d VDD VDD_M1_17_d 0.01
R_A_17_M1_17_g A_17 A_17_M1_17_g 0.01
R_N003_17_M1_17_s N003_17 N003_17_M1_17_s 0.01
R_VDD_M1_17_b VDD VDD_M1_17_b 0.01
M1_17 VDD_M1_17_d A_17_M1_17_g N003_17_M1_17_s VDD_M1_17_b pmos l=1u w=4u
R_N003_17_M2_17_d N003_17 N003_17_M2_17_d 0.01
R_B_17_M2_17_g B_17 B_17_M2_17_g 0.01
R_N005_17_M2_17_s N005_17 N005_17_M2_17_s 0.01
R_VDD_M2_17_b VDD VDD_M2_17_b 0.01
M2_17 N003_17_M2_17_d B_17_M2_17_g N005_17_M2_17_s VDD_M2_17_b pmos l=1u w=4u
R_VDD_M3_17_d VDD VDD_M3_17_d 0.01
R_A_17_M3_17_g A_17 A_17_M3_17_g 0.01
R_N001_17_M3_17_s N001_17 N001_17_M3_17_s 0.01
R_VDD_M3_17_b VDD VDD_M3_17_b 0.01
M3_17 VDD_M3_17_d A_17_M3_17_g N001_17_M3_17_s VDD_M3_17_b pmos l=1u w=4u
R_N001_17_M4_17_d N001_17 N001_17_M4_17_d 0.01
R_C_17_M4_17_g C_17 C_17_M4_17_g 0.01
R_N005_17_M4_17_s N005_17 N005_17_M4_17_s 0.01
R_VDD_M4_17_b VDD VDD_M4_17_b 0.01
M4_17 N001_17_M4_17_d C_17_M4_17_g N005_17_M4_17_s VDD_M4_17_b pmos l=1u w=4u
R_VDD_M5_17_d VDD VDD_M5_17_d 0.01
R_B_17_M5_17_g B_17 B_17_M5_17_g 0.01
R_N001_17_M5_17_s N001_17 N001_17_M5_17_s 0.01
R_VDD_M5_17_b VDD VDD_M5_17_b 0.01
M5_17 VDD_M5_17_d B_17_M5_17_g N001_17_M5_17_s VDD_M5_17_b pmos l=1u w=4u
R_VDD_M6_17_d VDD VDD_M6_17_d 0.01
R_N005_17_M6_17_g N005_17 N005_17_M6_17_g 0.01
R_C_18_M6_17_s C_18 C_18_M6_17_s 0.01
R_VDD_M6_17_b VDD VDD_M6_17_b 0.01
M6_17 VDD_M6_17_d N005_17_M6_17_g C_18_M6_17_s VDD_M6_17_b pmos l=1u w=2u
R_VDD_M7_17_d VDD VDD_M7_17_d 0.01
R_A_17_M7_17_g A_17 A_17_M7_17_g 0.01
R_N002_17_M7_17_s N002_17 N002_17_M7_17_s 0.01
R_VDD_M7_17_b VDD VDD_M7_17_b 0.01
M7_17 VDD_M7_17_d A_17_M7_17_g N002_17_M7_17_s VDD_M7_17_b pmos l=1u w=4u
R_VDD_M8_17_d VDD VDD_M8_17_d 0.01
R_B_17_M8_17_g B_17 B_17_M8_17_g 0.01
R_N002_17_M8_17_s N002_17 N002_17_M8_17_s 0.01
R_VDD_M8_17_b VDD VDD_M8_17_b 0.01
M8_17 VDD_M8_17_d B_17_M8_17_g N002_17_M8_17_s VDD_M8_17_b pmos l=1u w=4u
R_VDD_M9_17_d VDD VDD_M9_17_d 0.01
R_C_17_M9_17_g C_17 C_17_M9_17_g 0.01
R_N002_17_M9_17_s N002_17 N002_17_M9_17_s 0.01
R_VDD_M9_17_b VDD VDD_M9_17_b 0.01
M9_17 VDD_M9_17_d C_17_M9_17_g N002_17_M9_17_s VDD_M9_17_b pmos l=1u w=4u
R_VDD_M10_17_d VDD VDD_M10_17_d 0.01
R_A_17_M10_17_g A_17 A_17_M10_17_g 0.01
R_N004_17_M10_17_s N004_17 N004_17_M10_17_s 0.01
R_VDD_M10_17_b VDD VDD_M10_17_b 0.01
M10_17 VDD_M10_17_d A_17_M10_17_g N004_17_M10_17_s VDD_M10_17_b pmos l=1u w=8u
R_N004_17_M11_17_d N004_17 N004_17_M11_17_d 0.01
R_B_17_M11_17_g B_17 B_17_M11_17_g 0.01
R_N006_17_M11_17_s N006_17 N006_17_M11_17_s 0.01
R_VDD_M11_17_b VDD VDD_M11_17_b 0.01
M11_17 N004_17_M11_17_d B_17_M11_17_g N006_17_M11_17_s VDD_M11_17_b pmos l=1u w=8u
R_N006_17_M12_17_d N006_17 N006_17_M12_17_d 0.01
R_C_17_M12_17_g C_17 C_17_M12_17_g 0.01
R_N007_17_M12_17_s N007_17 N007_17_M12_17_s 0.01
R_VDD_M12_17_b VDD VDD_M12_17_b 0.01
M12_17 N006_17_M12_17_d C_17_M12_17_g N007_17_M12_17_s VDD_M12_17_b pmos l=1u w=8u
R_N007_17_M13_17_d N007_17 N007_17_M13_17_d 0.01
R_C_17_M13_17_g C_17 C_17_M13_17_g 0.01
R_N008_17_M13_17_s N008_17 N008_17_M13_17_s 0.01
M13_17 N007_17_M13_17_d C_17_M13_17_g N008_17_M13_17_s 0 nmos l=1u w=8u
R_N008_17_M14_17_d N008_17 N008_17_M14_17_d 0.01
R_B_17_M14_17_g B_17 B_17_M14_17_g 0.01
R_N012_17_M14_17_s N012_17 N012_17_M14_17_s 0.01
M14_17 N008_17_M14_17_d B_17_M14_17_g N012_17_M14_17_s 0 nmos l=1u w=8u
R_N012_17_M15_17_d N012_17 N012_17_M15_17_d 0.01
R_A_17_M15_17_g A_17 A_17_M15_17_g 0.01
M15_17 N012_17_M15_17_d A_17_M15_17_g 0 0 nmos l=1u w=8u
R_N010_17_M16_17_d N010_17 N010_17_M16_17_d 0.01
R_C_17_M16_17_g C_17 C_17_M16_17_g 0.01
M16_17 N010_17_M16_17_d C_17_M16_17_g 0 0 nmos l=1u w=2u
R_N010_17_M17_17_d N010_17 N010_17_M17_17_d 0.01
R_B_17_M17_17_g B_17 B_17_M17_17_g 0.01
M17_17 N010_17_M17_17_d B_17_M17_17_g 0 0 nmos l=1u w=2u
R_N010_17_M18_17_d N010_17 N010_17_M18_17_d 0.01
R_A_17_M18_17_g A_17 A_17_M18_17_g 0.01
M18_17 N010_17_M18_17_d A_17_M18_17_g 0 0 nmos l=1u w=2u
R_N007_17_M19_17_d N007_17 N007_17_M19_17_d 0.01
R_N005_17_M19_17_g N005_17 N005_17_M19_17_g 0.01
R_N010_17_M19_17_s N010_17 N010_17_M19_17_s 0.01
M19_17 N007_17_M19_17_d N005_17_M19_17_g N010_17_M19_17_s 0 nmos l=1u w=2u
R_N009_17_M20_17_d N009_17 N009_17_M20_17_d 0.01
R_B_17_M20_17_g B_17 B_17_M20_17_g 0.01
M20_17 N009_17_M20_17_d B_17_M20_17_g 0 0 nmos l=1u w=2u
R_N009_17_M21_17_d N009_17 N009_17_M21_17_d 0.01
R_A_17_M21_17_g A_17 A_17_M21_17_g 0.01
M21_17 N009_17_M21_17_d A_17_M21_17_g 0 0 nmos l=1u w=2u
R_N011_17_M22_17_d N011_17 N011_17_M22_17_d 0.01
R_A_17_M22_17_g A_17 A_17_M22_17_g 0.01
M22_17 N011_17_M22_17_d A_17_M22_17_g 0 0 nmos l=1u w=2u
R_N005_17_M23_17_d N005_17 N005_17_M23_17_d 0.01
R_B_17_M23_17_g B_17 B_17_M23_17_g 0.01
R_N011_17_M23_17_s N011_17 N011_17_M23_17_s 0.01
M23_17 N005_17_M23_17_d B_17_M23_17_g N011_17_M23_17_s 0 nmos l=1u w=2u
R_N005_17_M24_17_d N005_17 N005_17_M24_17_d 0.01
R_C_17_M24_17_g C_17 C_17_M24_17_g 0.01
R_N009_17_M24_17_s N009_17 N009_17_M24_17_s 0.01
M24_17 N005_17_M24_17_d C_17_M24_17_g N009_17_M24_17_s 0 nmos l=1u w=2u
R_C_18_M25_17_d C_18 C_18_M25_17_d 0.01
R_N005_17_M25_17_g N005_17 N005_17_M25_17_g 0.01
M25_17 C_18_M25_17_d N005_17_M25_17_g 0 0 nmos l=1u w=1u
R_N002_17_M26_17_d N002_17 N002_17_M26_17_d 0.01
R_N005_17_M26_17_g N005_17 N005_17_M26_17_g 0.01
R_N007_17_M26_17_s N007_17 N007_17_M26_17_s 0.01
R_VDD_M26_17_b VDD VDD_M26_17_b 0.01
M26_17 N002_17_M26_17_d N005_17_M26_17_g N007_17_M26_17_s VDD_M26_17_b pmos l=1u w=4u
R_VDD_M27_17_d VDD VDD_M27_17_d 0.01
R_N007_17_M27_17_g N007_17 N007_17_M27_17_g 0.01
R_S_17_M27_17_s S_17 S_17_M27_17_s 0.01
R_VDD_M27_17_b VDD VDD_M27_17_b 0.01
M27_17 VDD_M27_17_d N007_17_M27_17_g S_17_M27_17_s VDD_M27_17_b pmos l=1u w=2u
R_S_17_M28_17_d S_17 S_17_M28_17_d 0.01
R_N007_17_M28_17_g N007_17 N007_17_M28_17_g 0.01
M28_17 S_17_M28_17_d N007_17_M28_17_g 0 0 nmos l=1u w=1u
C_S_17 S_17 0 1f
* --- Bit 18 ---
R_VDD_M1_18_d VDD VDD_M1_18_d 0.01
R_A_18_M1_18_g A_18 A_18_M1_18_g 0.01
R_N003_18_M1_18_s N003_18 N003_18_M1_18_s 0.01
R_VDD_M1_18_b VDD VDD_M1_18_b 0.01
M1_18 VDD_M1_18_d A_18_M1_18_g N003_18_M1_18_s VDD_M1_18_b pmos l=1u w=4u
R_N003_18_M2_18_d N003_18 N003_18_M2_18_d 0.01
R_B_18_M2_18_g B_18 B_18_M2_18_g 0.01
R_N005_18_M2_18_s N005_18 N005_18_M2_18_s 0.01
R_VDD_M2_18_b VDD VDD_M2_18_b 0.01
M2_18 N003_18_M2_18_d B_18_M2_18_g N005_18_M2_18_s VDD_M2_18_b pmos l=1u w=4u
R_VDD_M3_18_d VDD VDD_M3_18_d 0.01
R_A_18_M3_18_g A_18 A_18_M3_18_g 0.01
R_N001_18_M3_18_s N001_18 N001_18_M3_18_s 0.01
R_VDD_M3_18_b VDD VDD_M3_18_b 0.01
M3_18 VDD_M3_18_d A_18_M3_18_g N001_18_M3_18_s VDD_M3_18_b pmos l=1u w=4u
R_N001_18_M4_18_d N001_18 N001_18_M4_18_d 0.01
R_C_18_M4_18_g C_18 C_18_M4_18_g 0.01
R_N005_18_M4_18_s N005_18 N005_18_M4_18_s 0.01
R_VDD_M4_18_b VDD VDD_M4_18_b 0.01
M4_18 N001_18_M4_18_d C_18_M4_18_g N005_18_M4_18_s VDD_M4_18_b pmos l=1u w=4u
R_VDD_M5_18_d VDD VDD_M5_18_d 0.01
R_B_18_M5_18_g B_18 B_18_M5_18_g 0.01
R_N001_18_M5_18_s N001_18 N001_18_M5_18_s 0.01
R_VDD_M5_18_b VDD VDD_M5_18_b 0.01
M5_18 VDD_M5_18_d B_18_M5_18_g N001_18_M5_18_s VDD_M5_18_b pmos l=1u w=4u
R_VDD_M6_18_d VDD VDD_M6_18_d 0.01
R_N005_18_M6_18_g N005_18 N005_18_M6_18_g 0.01
R_C_19_M6_18_s C_19 C_19_M6_18_s 0.01
R_VDD_M6_18_b VDD VDD_M6_18_b 0.01
M6_18 VDD_M6_18_d N005_18_M6_18_g C_19_M6_18_s VDD_M6_18_b pmos l=1u w=2u
R_VDD_M7_18_d VDD VDD_M7_18_d 0.01
R_A_18_M7_18_g A_18 A_18_M7_18_g 0.01
R_N002_18_M7_18_s N002_18 N002_18_M7_18_s 0.01
R_VDD_M7_18_b VDD VDD_M7_18_b 0.01
M7_18 VDD_M7_18_d A_18_M7_18_g N002_18_M7_18_s VDD_M7_18_b pmos l=1u w=4u
R_VDD_M8_18_d VDD VDD_M8_18_d 0.01
R_B_18_M8_18_g B_18 B_18_M8_18_g 0.01
R_N002_18_M8_18_s N002_18 N002_18_M8_18_s 0.01
R_VDD_M8_18_b VDD VDD_M8_18_b 0.01
M8_18 VDD_M8_18_d B_18_M8_18_g N002_18_M8_18_s VDD_M8_18_b pmos l=1u w=4u
R_VDD_M9_18_d VDD VDD_M9_18_d 0.01
R_C_18_M9_18_g C_18 C_18_M9_18_g 0.01
R_N002_18_M9_18_s N002_18 N002_18_M9_18_s 0.01
R_VDD_M9_18_b VDD VDD_M9_18_b 0.01
M9_18 VDD_M9_18_d C_18_M9_18_g N002_18_M9_18_s VDD_M9_18_b pmos l=1u w=4u
R_VDD_M10_18_d VDD VDD_M10_18_d 0.01
R_A_18_M10_18_g A_18 A_18_M10_18_g 0.01
R_N004_18_M10_18_s N004_18 N004_18_M10_18_s 0.01
R_VDD_M10_18_b VDD VDD_M10_18_b 0.01
M10_18 VDD_M10_18_d A_18_M10_18_g N004_18_M10_18_s VDD_M10_18_b pmos l=1u w=8u
R_N004_18_M11_18_d N004_18 N004_18_M11_18_d 0.01
R_B_18_M11_18_g B_18 B_18_M11_18_g 0.01
R_N006_18_M11_18_s N006_18 N006_18_M11_18_s 0.01
R_VDD_M11_18_b VDD VDD_M11_18_b 0.01
M11_18 N004_18_M11_18_d B_18_M11_18_g N006_18_M11_18_s VDD_M11_18_b pmos l=1u w=8u
R_N006_18_M12_18_d N006_18 N006_18_M12_18_d 0.01
R_C_18_M12_18_g C_18 C_18_M12_18_g 0.01
R_N007_18_M12_18_s N007_18 N007_18_M12_18_s 0.01
R_VDD_M12_18_b VDD VDD_M12_18_b 0.01
M12_18 N006_18_M12_18_d C_18_M12_18_g N007_18_M12_18_s VDD_M12_18_b pmos l=1u w=8u
R_N007_18_M13_18_d N007_18 N007_18_M13_18_d 0.01
R_C_18_M13_18_g C_18 C_18_M13_18_g 0.01
R_N008_18_M13_18_s N008_18 N008_18_M13_18_s 0.01
M13_18 N007_18_M13_18_d C_18_M13_18_g N008_18_M13_18_s 0 nmos l=1u w=8u
R_N008_18_M14_18_d N008_18 N008_18_M14_18_d 0.01
R_B_18_M14_18_g B_18 B_18_M14_18_g 0.01
R_N012_18_M14_18_s N012_18 N012_18_M14_18_s 0.01
M14_18 N008_18_M14_18_d B_18_M14_18_g N012_18_M14_18_s 0 nmos l=1u w=8u
R_N012_18_M15_18_d N012_18 N012_18_M15_18_d 0.01
R_A_18_M15_18_g A_18 A_18_M15_18_g 0.01
M15_18 N012_18_M15_18_d A_18_M15_18_g 0 0 nmos l=1u w=8u
R_N010_18_M16_18_d N010_18 N010_18_M16_18_d 0.01
R_C_18_M16_18_g C_18 C_18_M16_18_g 0.01
M16_18 N010_18_M16_18_d C_18_M16_18_g 0 0 nmos l=1u w=2u
R_N010_18_M17_18_d N010_18 N010_18_M17_18_d 0.01
R_B_18_M17_18_g B_18 B_18_M17_18_g 0.01
M17_18 N010_18_M17_18_d B_18_M17_18_g 0 0 nmos l=1u w=2u
R_N010_18_M18_18_d N010_18 N010_18_M18_18_d 0.01
R_A_18_M18_18_g A_18 A_18_M18_18_g 0.01
M18_18 N010_18_M18_18_d A_18_M18_18_g 0 0 nmos l=1u w=2u
R_N007_18_M19_18_d N007_18 N007_18_M19_18_d 0.01
R_N005_18_M19_18_g N005_18 N005_18_M19_18_g 0.01
R_N010_18_M19_18_s N010_18 N010_18_M19_18_s 0.01
M19_18 N007_18_M19_18_d N005_18_M19_18_g N010_18_M19_18_s 0 nmos l=1u w=2u
R_N009_18_M20_18_d N009_18 N009_18_M20_18_d 0.01
R_B_18_M20_18_g B_18 B_18_M20_18_g 0.01
M20_18 N009_18_M20_18_d B_18_M20_18_g 0 0 nmos l=1u w=2u
R_N009_18_M21_18_d N009_18 N009_18_M21_18_d 0.01
R_A_18_M21_18_g A_18 A_18_M21_18_g 0.01
M21_18 N009_18_M21_18_d A_18_M21_18_g 0 0 nmos l=1u w=2u
R_N011_18_M22_18_d N011_18 N011_18_M22_18_d 0.01
R_A_18_M22_18_g A_18 A_18_M22_18_g 0.01
M22_18 N011_18_M22_18_d A_18_M22_18_g 0 0 nmos l=1u w=2u
R_N005_18_M23_18_d N005_18 N005_18_M23_18_d 0.01
R_B_18_M23_18_g B_18 B_18_M23_18_g 0.01
R_N011_18_M23_18_s N011_18 N011_18_M23_18_s 0.01
M23_18 N005_18_M23_18_d B_18_M23_18_g N011_18_M23_18_s 0 nmos l=1u w=2u
R_N005_18_M24_18_d N005_18 N005_18_M24_18_d 0.01
R_C_18_M24_18_g C_18 C_18_M24_18_g 0.01
R_N009_18_M24_18_s N009_18 N009_18_M24_18_s 0.01
M24_18 N005_18_M24_18_d C_18_M24_18_g N009_18_M24_18_s 0 nmos l=1u w=2u
R_C_19_M25_18_d C_19 C_19_M25_18_d 0.01
R_N005_18_M25_18_g N005_18 N005_18_M25_18_g 0.01
M25_18 C_19_M25_18_d N005_18_M25_18_g 0 0 nmos l=1u w=1u
R_N002_18_M26_18_d N002_18 N002_18_M26_18_d 0.01
R_N005_18_M26_18_g N005_18 N005_18_M26_18_g 0.01
R_N007_18_M26_18_s N007_18 N007_18_M26_18_s 0.01
R_VDD_M26_18_b VDD VDD_M26_18_b 0.01
M26_18 N002_18_M26_18_d N005_18_M26_18_g N007_18_M26_18_s VDD_M26_18_b pmos l=1u w=4u
R_VDD_M27_18_d VDD VDD_M27_18_d 0.01
R_N007_18_M27_18_g N007_18 N007_18_M27_18_g 0.01
R_S_18_M27_18_s S_18 S_18_M27_18_s 0.01
R_VDD_M27_18_b VDD VDD_M27_18_b 0.01
M27_18 VDD_M27_18_d N007_18_M27_18_g S_18_M27_18_s VDD_M27_18_b pmos l=1u w=2u
R_S_18_M28_18_d S_18 S_18_M28_18_d 0.01
R_N007_18_M28_18_g N007_18 N007_18_M28_18_g 0.01
M28_18 S_18_M28_18_d N007_18_M28_18_g 0 0 nmos l=1u w=1u
C_S_18 S_18 0 1f
* --- Bit 19 ---
R_VDD_M1_19_d VDD VDD_M1_19_d 0.01
R_A_19_M1_19_g A_19 A_19_M1_19_g 0.01
R_N003_19_M1_19_s N003_19 N003_19_M1_19_s 0.01
R_VDD_M1_19_b VDD VDD_M1_19_b 0.01
M1_19 VDD_M1_19_d A_19_M1_19_g N003_19_M1_19_s VDD_M1_19_b pmos l=1u w=4u
R_N003_19_M2_19_d N003_19 N003_19_M2_19_d 0.01
R_B_19_M2_19_g B_19 B_19_M2_19_g 0.01
R_N005_19_M2_19_s N005_19 N005_19_M2_19_s 0.01
R_VDD_M2_19_b VDD VDD_M2_19_b 0.01
M2_19 N003_19_M2_19_d B_19_M2_19_g N005_19_M2_19_s VDD_M2_19_b pmos l=1u w=4u
R_VDD_M3_19_d VDD VDD_M3_19_d 0.01
R_A_19_M3_19_g A_19 A_19_M3_19_g 0.01
R_N001_19_M3_19_s N001_19 N001_19_M3_19_s 0.01
R_VDD_M3_19_b VDD VDD_M3_19_b 0.01
M3_19 VDD_M3_19_d A_19_M3_19_g N001_19_M3_19_s VDD_M3_19_b pmos l=1u w=4u
R_N001_19_M4_19_d N001_19 N001_19_M4_19_d 0.01
R_C_19_M4_19_g C_19 C_19_M4_19_g 0.01
R_N005_19_M4_19_s N005_19 N005_19_M4_19_s 0.01
R_VDD_M4_19_b VDD VDD_M4_19_b 0.01
M4_19 N001_19_M4_19_d C_19_M4_19_g N005_19_M4_19_s VDD_M4_19_b pmos l=1u w=4u
R_VDD_M5_19_d VDD VDD_M5_19_d 0.01
R_B_19_M5_19_g B_19 B_19_M5_19_g 0.01
R_N001_19_M5_19_s N001_19 N001_19_M5_19_s 0.01
R_VDD_M5_19_b VDD VDD_M5_19_b 0.01
M5_19 VDD_M5_19_d B_19_M5_19_g N001_19_M5_19_s VDD_M5_19_b pmos l=1u w=4u
R_VDD_M6_19_d VDD VDD_M6_19_d 0.01
R_N005_19_M6_19_g N005_19 N005_19_M6_19_g 0.01
R_C_20_M6_19_s C_20 C_20_M6_19_s 0.01
R_VDD_M6_19_b VDD VDD_M6_19_b 0.01
M6_19 VDD_M6_19_d N005_19_M6_19_g C_20_M6_19_s VDD_M6_19_b pmos l=1u w=2u
R_VDD_M7_19_d VDD VDD_M7_19_d 0.01
R_A_19_M7_19_g A_19 A_19_M7_19_g 0.01
R_N002_19_M7_19_s N002_19 N002_19_M7_19_s 0.01
R_VDD_M7_19_b VDD VDD_M7_19_b 0.01
M7_19 VDD_M7_19_d A_19_M7_19_g N002_19_M7_19_s VDD_M7_19_b pmos l=1u w=4u
R_VDD_M8_19_d VDD VDD_M8_19_d 0.01
R_B_19_M8_19_g B_19 B_19_M8_19_g 0.01
R_N002_19_M8_19_s N002_19 N002_19_M8_19_s 0.01
R_VDD_M8_19_b VDD VDD_M8_19_b 0.01
M8_19 VDD_M8_19_d B_19_M8_19_g N002_19_M8_19_s VDD_M8_19_b pmos l=1u w=4u
R_VDD_M9_19_d VDD VDD_M9_19_d 0.01
R_C_19_M9_19_g C_19 C_19_M9_19_g 0.01
R_N002_19_M9_19_s N002_19 N002_19_M9_19_s 0.01
R_VDD_M9_19_b VDD VDD_M9_19_b 0.01
M9_19 VDD_M9_19_d C_19_M9_19_g N002_19_M9_19_s VDD_M9_19_b pmos l=1u w=4u
R_VDD_M10_19_d VDD VDD_M10_19_d 0.01
R_A_19_M10_19_g A_19 A_19_M10_19_g 0.01
R_N004_19_M10_19_s N004_19 N004_19_M10_19_s 0.01
R_VDD_M10_19_b VDD VDD_M10_19_b 0.01
M10_19 VDD_M10_19_d A_19_M10_19_g N004_19_M10_19_s VDD_M10_19_b pmos l=1u w=8u
R_N004_19_M11_19_d N004_19 N004_19_M11_19_d 0.01
R_B_19_M11_19_g B_19 B_19_M11_19_g 0.01
R_N006_19_M11_19_s N006_19 N006_19_M11_19_s 0.01
R_VDD_M11_19_b VDD VDD_M11_19_b 0.01
M11_19 N004_19_M11_19_d B_19_M11_19_g N006_19_M11_19_s VDD_M11_19_b pmos l=1u w=8u
R_N006_19_M12_19_d N006_19 N006_19_M12_19_d 0.01
R_C_19_M12_19_g C_19 C_19_M12_19_g 0.01
R_N007_19_M12_19_s N007_19 N007_19_M12_19_s 0.01
R_VDD_M12_19_b VDD VDD_M12_19_b 0.01
M12_19 N006_19_M12_19_d C_19_M12_19_g N007_19_M12_19_s VDD_M12_19_b pmos l=1u w=8u
R_N007_19_M13_19_d N007_19 N007_19_M13_19_d 0.01
R_C_19_M13_19_g C_19 C_19_M13_19_g 0.01
R_N008_19_M13_19_s N008_19 N008_19_M13_19_s 0.01
M13_19 N007_19_M13_19_d C_19_M13_19_g N008_19_M13_19_s 0 nmos l=1u w=8u
R_N008_19_M14_19_d N008_19 N008_19_M14_19_d 0.01
R_B_19_M14_19_g B_19 B_19_M14_19_g 0.01
R_N012_19_M14_19_s N012_19 N012_19_M14_19_s 0.01
M14_19 N008_19_M14_19_d B_19_M14_19_g N012_19_M14_19_s 0 nmos l=1u w=8u
R_N012_19_M15_19_d N012_19 N012_19_M15_19_d 0.01
R_A_19_M15_19_g A_19 A_19_M15_19_g 0.01
M15_19 N012_19_M15_19_d A_19_M15_19_g 0 0 nmos l=1u w=8u
R_N010_19_M16_19_d N010_19 N010_19_M16_19_d 0.01
R_C_19_M16_19_g C_19 C_19_M16_19_g 0.01
M16_19 N010_19_M16_19_d C_19_M16_19_g 0 0 nmos l=1u w=2u
R_N010_19_M17_19_d N010_19 N010_19_M17_19_d 0.01
R_B_19_M17_19_g B_19 B_19_M17_19_g 0.01
M17_19 N010_19_M17_19_d B_19_M17_19_g 0 0 nmos l=1u w=2u
R_N010_19_M18_19_d N010_19 N010_19_M18_19_d 0.01
R_A_19_M18_19_g A_19 A_19_M18_19_g 0.01
M18_19 N010_19_M18_19_d A_19_M18_19_g 0 0 nmos l=1u w=2u
R_N007_19_M19_19_d N007_19 N007_19_M19_19_d 0.01
R_N005_19_M19_19_g N005_19 N005_19_M19_19_g 0.01
R_N010_19_M19_19_s N010_19 N010_19_M19_19_s 0.01
M19_19 N007_19_M19_19_d N005_19_M19_19_g N010_19_M19_19_s 0 nmos l=1u w=2u
R_N009_19_M20_19_d N009_19 N009_19_M20_19_d 0.01
R_B_19_M20_19_g B_19 B_19_M20_19_g 0.01
M20_19 N009_19_M20_19_d B_19_M20_19_g 0 0 nmos l=1u w=2u
R_N009_19_M21_19_d N009_19 N009_19_M21_19_d 0.01
R_A_19_M21_19_g A_19 A_19_M21_19_g 0.01
M21_19 N009_19_M21_19_d A_19_M21_19_g 0 0 nmos l=1u w=2u
R_N011_19_M22_19_d N011_19 N011_19_M22_19_d 0.01
R_A_19_M22_19_g A_19 A_19_M22_19_g 0.01
M22_19 N011_19_M22_19_d A_19_M22_19_g 0 0 nmos l=1u w=2u
R_N005_19_M23_19_d N005_19 N005_19_M23_19_d 0.01
R_B_19_M23_19_g B_19 B_19_M23_19_g 0.01
R_N011_19_M23_19_s N011_19 N011_19_M23_19_s 0.01
M23_19 N005_19_M23_19_d B_19_M23_19_g N011_19_M23_19_s 0 nmos l=1u w=2u
R_N005_19_M24_19_d N005_19 N005_19_M24_19_d 0.01
R_C_19_M24_19_g C_19 C_19_M24_19_g 0.01
R_N009_19_M24_19_s N009_19 N009_19_M24_19_s 0.01
M24_19 N005_19_M24_19_d C_19_M24_19_g N009_19_M24_19_s 0 nmos l=1u w=2u
R_C_20_M25_19_d C_20 C_20_M25_19_d 0.01
R_N005_19_M25_19_g N005_19 N005_19_M25_19_g 0.01
M25_19 C_20_M25_19_d N005_19_M25_19_g 0 0 nmos l=1u w=1u
R_N002_19_M26_19_d N002_19 N002_19_M26_19_d 0.01
R_N005_19_M26_19_g N005_19 N005_19_M26_19_g 0.01
R_N007_19_M26_19_s N007_19 N007_19_M26_19_s 0.01
R_VDD_M26_19_b VDD VDD_M26_19_b 0.01
M26_19 N002_19_M26_19_d N005_19_M26_19_g N007_19_M26_19_s VDD_M26_19_b pmos l=1u w=4u
R_VDD_M27_19_d VDD VDD_M27_19_d 0.01
R_N007_19_M27_19_g N007_19 N007_19_M27_19_g 0.01
R_S_19_M27_19_s S_19 S_19_M27_19_s 0.01
R_VDD_M27_19_b VDD VDD_M27_19_b 0.01
M27_19 VDD_M27_19_d N007_19_M27_19_g S_19_M27_19_s VDD_M27_19_b pmos l=1u w=2u
R_S_19_M28_19_d S_19 S_19_M28_19_d 0.01
R_N007_19_M28_19_g N007_19 N007_19_M28_19_g 0.01
M28_19 S_19_M28_19_d N007_19_M28_19_g 0 0 nmos l=1u w=1u
C_S_19 S_19 0 1f
* --- Bit 20 ---
R_VDD_M1_20_d VDD VDD_M1_20_d 0.01
R_A_20_M1_20_g A_20 A_20_M1_20_g 0.01
R_N003_20_M1_20_s N003_20 N003_20_M1_20_s 0.01
R_VDD_M1_20_b VDD VDD_M1_20_b 0.01
M1_20 VDD_M1_20_d A_20_M1_20_g N003_20_M1_20_s VDD_M1_20_b pmos l=1u w=4u
R_N003_20_M2_20_d N003_20 N003_20_M2_20_d 0.01
R_B_20_M2_20_g B_20 B_20_M2_20_g 0.01
R_N005_20_M2_20_s N005_20 N005_20_M2_20_s 0.01
R_VDD_M2_20_b VDD VDD_M2_20_b 0.01
M2_20 N003_20_M2_20_d B_20_M2_20_g N005_20_M2_20_s VDD_M2_20_b pmos l=1u w=4u
R_VDD_M3_20_d VDD VDD_M3_20_d 0.01
R_A_20_M3_20_g A_20 A_20_M3_20_g 0.01
R_N001_20_M3_20_s N001_20 N001_20_M3_20_s 0.01
R_VDD_M3_20_b VDD VDD_M3_20_b 0.01
M3_20 VDD_M3_20_d A_20_M3_20_g N001_20_M3_20_s VDD_M3_20_b pmos l=1u w=4u
R_N001_20_M4_20_d N001_20 N001_20_M4_20_d 0.01
R_C_20_M4_20_g C_20 C_20_M4_20_g 0.01
R_N005_20_M4_20_s N005_20 N005_20_M4_20_s 0.01
R_VDD_M4_20_b VDD VDD_M4_20_b 0.01
M4_20 N001_20_M4_20_d C_20_M4_20_g N005_20_M4_20_s VDD_M4_20_b pmos l=1u w=4u
R_VDD_M5_20_d VDD VDD_M5_20_d 0.01
R_B_20_M5_20_g B_20 B_20_M5_20_g 0.01
R_N001_20_M5_20_s N001_20 N001_20_M5_20_s 0.01
R_VDD_M5_20_b VDD VDD_M5_20_b 0.01
M5_20 VDD_M5_20_d B_20_M5_20_g N001_20_M5_20_s VDD_M5_20_b pmos l=1u w=4u
R_VDD_M6_20_d VDD VDD_M6_20_d 0.01
R_N005_20_M6_20_g N005_20 N005_20_M6_20_g 0.01
R_C_21_M6_20_s C_21 C_21_M6_20_s 0.01
R_VDD_M6_20_b VDD VDD_M6_20_b 0.01
M6_20 VDD_M6_20_d N005_20_M6_20_g C_21_M6_20_s VDD_M6_20_b pmos l=1u w=2u
R_VDD_M7_20_d VDD VDD_M7_20_d 0.01
R_A_20_M7_20_g A_20 A_20_M7_20_g 0.01
R_N002_20_M7_20_s N002_20 N002_20_M7_20_s 0.01
R_VDD_M7_20_b VDD VDD_M7_20_b 0.01
M7_20 VDD_M7_20_d A_20_M7_20_g N002_20_M7_20_s VDD_M7_20_b pmos l=1u w=4u
R_VDD_M8_20_d VDD VDD_M8_20_d 0.01
R_B_20_M8_20_g B_20 B_20_M8_20_g 0.01
R_N002_20_M8_20_s N002_20 N002_20_M8_20_s 0.01
R_VDD_M8_20_b VDD VDD_M8_20_b 0.01
M8_20 VDD_M8_20_d B_20_M8_20_g N002_20_M8_20_s VDD_M8_20_b pmos l=1u w=4u
R_VDD_M9_20_d VDD VDD_M9_20_d 0.01
R_C_20_M9_20_g C_20 C_20_M9_20_g 0.01
R_N002_20_M9_20_s N002_20 N002_20_M9_20_s 0.01
R_VDD_M9_20_b VDD VDD_M9_20_b 0.01
M9_20 VDD_M9_20_d C_20_M9_20_g N002_20_M9_20_s VDD_M9_20_b pmos l=1u w=4u
R_VDD_M10_20_d VDD VDD_M10_20_d 0.01
R_A_20_M10_20_g A_20 A_20_M10_20_g 0.01
R_N004_20_M10_20_s N004_20 N004_20_M10_20_s 0.01
R_VDD_M10_20_b VDD VDD_M10_20_b 0.01
M10_20 VDD_M10_20_d A_20_M10_20_g N004_20_M10_20_s VDD_M10_20_b pmos l=1u w=8u
R_N004_20_M11_20_d N004_20 N004_20_M11_20_d 0.01
R_B_20_M11_20_g B_20 B_20_M11_20_g 0.01
R_N006_20_M11_20_s N006_20 N006_20_M11_20_s 0.01
R_VDD_M11_20_b VDD VDD_M11_20_b 0.01
M11_20 N004_20_M11_20_d B_20_M11_20_g N006_20_M11_20_s VDD_M11_20_b pmos l=1u w=8u
R_N006_20_M12_20_d N006_20 N006_20_M12_20_d 0.01
R_C_20_M12_20_g C_20 C_20_M12_20_g 0.01
R_N007_20_M12_20_s N007_20 N007_20_M12_20_s 0.01
R_VDD_M12_20_b VDD VDD_M12_20_b 0.01
M12_20 N006_20_M12_20_d C_20_M12_20_g N007_20_M12_20_s VDD_M12_20_b pmos l=1u w=8u
R_N007_20_M13_20_d N007_20 N007_20_M13_20_d 0.01
R_C_20_M13_20_g C_20 C_20_M13_20_g 0.01
R_N008_20_M13_20_s N008_20 N008_20_M13_20_s 0.01
M13_20 N007_20_M13_20_d C_20_M13_20_g N008_20_M13_20_s 0 nmos l=1u w=8u
R_N008_20_M14_20_d N008_20 N008_20_M14_20_d 0.01
R_B_20_M14_20_g B_20 B_20_M14_20_g 0.01
R_N012_20_M14_20_s N012_20 N012_20_M14_20_s 0.01
M14_20 N008_20_M14_20_d B_20_M14_20_g N012_20_M14_20_s 0 nmos l=1u w=8u
R_N012_20_M15_20_d N012_20 N012_20_M15_20_d 0.01
R_A_20_M15_20_g A_20 A_20_M15_20_g 0.01
M15_20 N012_20_M15_20_d A_20_M15_20_g 0 0 nmos l=1u w=8u
R_N010_20_M16_20_d N010_20 N010_20_M16_20_d 0.01
R_C_20_M16_20_g C_20 C_20_M16_20_g 0.01
M16_20 N010_20_M16_20_d C_20_M16_20_g 0 0 nmos l=1u w=2u
R_N010_20_M17_20_d N010_20 N010_20_M17_20_d 0.01
R_B_20_M17_20_g B_20 B_20_M17_20_g 0.01
M17_20 N010_20_M17_20_d B_20_M17_20_g 0 0 nmos l=1u w=2u
R_N010_20_M18_20_d N010_20 N010_20_M18_20_d 0.01
R_A_20_M18_20_g A_20 A_20_M18_20_g 0.01
M18_20 N010_20_M18_20_d A_20_M18_20_g 0 0 nmos l=1u w=2u
R_N007_20_M19_20_d N007_20 N007_20_M19_20_d 0.01
R_N005_20_M19_20_g N005_20 N005_20_M19_20_g 0.01
R_N010_20_M19_20_s N010_20 N010_20_M19_20_s 0.01
M19_20 N007_20_M19_20_d N005_20_M19_20_g N010_20_M19_20_s 0 nmos l=1u w=2u
R_N009_20_M20_20_d N009_20 N009_20_M20_20_d 0.01
R_B_20_M20_20_g B_20 B_20_M20_20_g 0.01
M20_20 N009_20_M20_20_d B_20_M20_20_g 0 0 nmos l=1u w=2u
R_N009_20_M21_20_d N009_20 N009_20_M21_20_d 0.01
R_A_20_M21_20_g A_20 A_20_M21_20_g 0.01
M21_20 N009_20_M21_20_d A_20_M21_20_g 0 0 nmos l=1u w=2u
R_N011_20_M22_20_d N011_20 N011_20_M22_20_d 0.01
R_A_20_M22_20_g A_20 A_20_M22_20_g 0.01
M22_20 N011_20_M22_20_d A_20_M22_20_g 0 0 nmos l=1u w=2u
R_N005_20_M23_20_d N005_20 N005_20_M23_20_d 0.01
R_B_20_M23_20_g B_20 B_20_M23_20_g 0.01
R_N011_20_M23_20_s N011_20 N011_20_M23_20_s 0.01
M23_20 N005_20_M23_20_d B_20_M23_20_g N011_20_M23_20_s 0 nmos l=1u w=2u
R_N005_20_M24_20_d N005_20 N005_20_M24_20_d 0.01
R_C_20_M24_20_g C_20 C_20_M24_20_g 0.01
R_N009_20_M24_20_s N009_20 N009_20_M24_20_s 0.01
M24_20 N005_20_M24_20_d C_20_M24_20_g N009_20_M24_20_s 0 nmos l=1u w=2u
R_C_21_M25_20_d C_21 C_21_M25_20_d 0.01
R_N005_20_M25_20_g N005_20 N005_20_M25_20_g 0.01
M25_20 C_21_M25_20_d N005_20_M25_20_g 0 0 nmos l=1u w=1u
R_N002_20_M26_20_d N002_20 N002_20_M26_20_d 0.01
R_N005_20_M26_20_g N005_20 N005_20_M26_20_g 0.01
R_N007_20_M26_20_s N007_20 N007_20_M26_20_s 0.01
R_VDD_M26_20_b VDD VDD_M26_20_b 0.01
M26_20 N002_20_M26_20_d N005_20_M26_20_g N007_20_M26_20_s VDD_M26_20_b pmos l=1u w=4u
R_VDD_M27_20_d VDD VDD_M27_20_d 0.01
R_N007_20_M27_20_g N007_20 N007_20_M27_20_g 0.01
R_S_20_M27_20_s S_20 S_20_M27_20_s 0.01
R_VDD_M27_20_b VDD VDD_M27_20_b 0.01
M27_20 VDD_M27_20_d N007_20_M27_20_g S_20_M27_20_s VDD_M27_20_b pmos l=1u w=2u
R_S_20_M28_20_d S_20 S_20_M28_20_d 0.01
R_N007_20_M28_20_g N007_20 N007_20_M28_20_g 0.01
M28_20 S_20_M28_20_d N007_20_M28_20_g 0 0 nmos l=1u w=1u
C_S_20 S_20 0 1f
* --- Bit 21 ---
R_VDD_M1_21_d VDD VDD_M1_21_d 0.01
R_A_21_M1_21_g A_21 A_21_M1_21_g 0.01
R_N003_21_M1_21_s N003_21 N003_21_M1_21_s 0.01
R_VDD_M1_21_b VDD VDD_M1_21_b 0.01
M1_21 VDD_M1_21_d A_21_M1_21_g N003_21_M1_21_s VDD_M1_21_b pmos l=1u w=4u
R_N003_21_M2_21_d N003_21 N003_21_M2_21_d 0.01
R_B_21_M2_21_g B_21 B_21_M2_21_g 0.01
R_N005_21_M2_21_s N005_21 N005_21_M2_21_s 0.01
R_VDD_M2_21_b VDD VDD_M2_21_b 0.01
M2_21 N003_21_M2_21_d B_21_M2_21_g N005_21_M2_21_s VDD_M2_21_b pmos l=1u w=4u
R_VDD_M3_21_d VDD VDD_M3_21_d 0.01
R_A_21_M3_21_g A_21 A_21_M3_21_g 0.01
R_N001_21_M3_21_s N001_21 N001_21_M3_21_s 0.01
R_VDD_M3_21_b VDD VDD_M3_21_b 0.01
M3_21 VDD_M3_21_d A_21_M3_21_g N001_21_M3_21_s VDD_M3_21_b pmos l=1u w=4u
R_N001_21_M4_21_d N001_21 N001_21_M4_21_d 0.01
R_C_21_M4_21_g C_21 C_21_M4_21_g 0.01
R_N005_21_M4_21_s N005_21 N005_21_M4_21_s 0.01
R_VDD_M4_21_b VDD VDD_M4_21_b 0.01
M4_21 N001_21_M4_21_d C_21_M4_21_g N005_21_M4_21_s VDD_M4_21_b pmos l=1u w=4u
R_VDD_M5_21_d VDD VDD_M5_21_d 0.01
R_B_21_M5_21_g B_21 B_21_M5_21_g 0.01
R_N001_21_M5_21_s N001_21 N001_21_M5_21_s 0.01
R_VDD_M5_21_b VDD VDD_M5_21_b 0.01
M5_21 VDD_M5_21_d B_21_M5_21_g N001_21_M5_21_s VDD_M5_21_b pmos l=1u w=4u
R_VDD_M6_21_d VDD VDD_M6_21_d 0.01
R_N005_21_M6_21_g N005_21 N005_21_M6_21_g 0.01
R_C_22_M6_21_s C_22 C_22_M6_21_s 0.01
R_VDD_M6_21_b VDD VDD_M6_21_b 0.01
M6_21 VDD_M6_21_d N005_21_M6_21_g C_22_M6_21_s VDD_M6_21_b pmos l=1u w=2u
R_VDD_M7_21_d VDD VDD_M7_21_d 0.01
R_A_21_M7_21_g A_21 A_21_M7_21_g 0.01
R_N002_21_M7_21_s N002_21 N002_21_M7_21_s 0.01
R_VDD_M7_21_b VDD VDD_M7_21_b 0.01
M7_21 VDD_M7_21_d A_21_M7_21_g N002_21_M7_21_s VDD_M7_21_b pmos l=1u w=4u
R_VDD_M8_21_d VDD VDD_M8_21_d 0.01
R_B_21_M8_21_g B_21 B_21_M8_21_g 0.01
R_N002_21_M8_21_s N002_21 N002_21_M8_21_s 0.01
R_VDD_M8_21_b VDD VDD_M8_21_b 0.01
M8_21 VDD_M8_21_d B_21_M8_21_g N002_21_M8_21_s VDD_M8_21_b pmos l=1u w=4u
R_VDD_M9_21_d VDD VDD_M9_21_d 0.01
R_C_21_M9_21_g C_21 C_21_M9_21_g 0.01
R_N002_21_M9_21_s N002_21 N002_21_M9_21_s 0.01
R_VDD_M9_21_b VDD VDD_M9_21_b 0.01
M9_21 VDD_M9_21_d C_21_M9_21_g N002_21_M9_21_s VDD_M9_21_b pmos l=1u w=4u
R_VDD_M10_21_d VDD VDD_M10_21_d 0.01
R_A_21_M10_21_g A_21 A_21_M10_21_g 0.01
R_N004_21_M10_21_s N004_21 N004_21_M10_21_s 0.01
R_VDD_M10_21_b VDD VDD_M10_21_b 0.01
M10_21 VDD_M10_21_d A_21_M10_21_g N004_21_M10_21_s VDD_M10_21_b pmos l=1u w=8u
R_N004_21_M11_21_d N004_21 N004_21_M11_21_d 0.01
R_B_21_M11_21_g B_21 B_21_M11_21_g 0.01
R_N006_21_M11_21_s N006_21 N006_21_M11_21_s 0.01
R_VDD_M11_21_b VDD VDD_M11_21_b 0.01
M11_21 N004_21_M11_21_d B_21_M11_21_g N006_21_M11_21_s VDD_M11_21_b pmos l=1u w=8u
R_N006_21_M12_21_d N006_21 N006_21_M12_21_d 0.01
R_C_21_M12_21_g C_21 C_21_M12_21_g 0.01
R_N007_21_M12_21_s N007_21 N007_21_M12_21_s 0.01
R_VDD_M12_21_b VDD VDD_M12_21_b 0.01
M12_21 N006_21_M12_21_d C_21_M12_21_g N007_21_M12_21_s VDD_M12_21_b pmos l=1u w=8u
R_N007_21_M13_21_d N007_21 N007_21_M13_21_d 0.01
R_C_21_M13_21_g C_21 C_21_M13_21_g 0.01
R_N008_21_M13_21_s N008_21 N008_21_M13_21_s 0.01
M13_21 N007_21_M13_21_d C_21_M13_21_g N008_21_M13_21_s 0 nmos l=1u w=8u
R_N008_21_M14_21_d N008_21 N008_21_M14_21_d 0.01
R_B_21_M14_21_g B_21 B_21_M14_21_g 0.01
R_N012_21_M14_21_s N012_21 N012_21_M14_21_s 0.01
M14_21 N008_21_M14_21_d B_21_M14_21_g N012_21_M14_21_s 0 nmos l=1u w=8u
R_N012_21_M15_21_d N012_21 N012_21_M15_21_d 0.01
R_A_21_M15_21_g A_21 A_21_M15_21_g 0.01
M15_21 N012_21_M15_21_d A_21_M15_21_g 0 0 nmos l=1u w=8u
R_N010_21_M16_21_d N010_21 N010_21_M16_21_d 0.01
R_C_21_M16_21_g C_21 C_21_M16_21_g 0.01
M16_21 N010_21_M16_21_d C_21_M16_21_g 0 0 nmos l=1u w=2u
R_N010_21_M17_21_d N010_21 N010_21_M17_21_d 0.01
R_B_21_M17_21_g B_21 B_21_M17_21_g 0.01
M17_21 N010_21_M17_21_d B_21_M17_21_g 0 0 nmos l=1u w=2u
R_N010_21_M18_21_d N010_21 N010_21_M18_21_d 0.01
R_A_21_M18_21_g A_21 A_21_M18_21_g 0.01
M18_21 N010_21_M18_21_d A_21_M18_21_g 0 0 nmos l=1u w=2u
R_N007_21_M19_21_d N007_21 N007_21_M19_21_d 0.01
R_N005_21_M19_21_g N005_21 N005_21_M19_21_g 0.01
R_N010_21_M19_21_s N010_21 N010_21_M19_21_s 0.01
M19_21 N007_21_M19_21_d N005_21_M19_21_g N010_21_M19_21_s 0 nmos l=1u w=2u
R_N009_21_M20_21_d N009_21 N009_21_M20_21_d 0.01
R_B_21_M20_21_g B_21 B_21_M20_21_g 0.01
M20_21 N009_21_M20_21_d B_21_M20_21_g 0 0 nmos l=1u w=2u
R_N009_21_M21_21_d N009_21 N009_21_M21_21_d 0.01
R_A_21_M21_21_g A_21 A_21_M21_21_g 0.01
M21_21 N009_21_M21_21_d A_21_M21_21_g 0 0 nmos l=1u w=2u
R_N011_21_M22_21_d N011_21 N011_21_M22_21_d 0.01
R_A_21_M22_21_g A_21 A_21_M22_21_g 0.01
M22_21 N011_21_M22_21_d A_21_M22_21_g 0 0 nmos l=1u w=2u
R_N005_21_M23_21_d N005_21 N005_21_M23_21_d 0.01
R_B_21_M23_21_g B_21 B_21_M23_21_g 0.01
R_N011_21_M23_21_s N011_21 N011_21_M23_21_s 0.01
M23_21 N005_21_M23_21_d B_21_M23_21_g N011_21_M23_21_s 0 nmos l=1u w=2u
R_N005_21_M24_21_d N005_21 N005_21_M24_21_d 0.01
R_C_21_M24_21_g C_21 C_21_M24_21_g 0.01
R_N009_21_M24_21_s N009_21 N009_21_M24_21_s 0.01
M24_21 N005_21_M24_21_d C_21_M24_21_g N009_21_M24_21_s 0 nmos l=1u w=2u
R_C_22_M25_21_d C_22 C_22_M25_21_d 0.01
R_N005_21_M25_21_g N005_21 N005_21_M25_21_g 0.01
M25_21 C_22_M25_21_d N005_21_M25_21_g 0 0 nmos l=1u w=1u
R_N002_21_M26_21_d N002_21 N002_21_M26_21_d 0.01
R_N005_21_M26_21_g N005_21 N005_21_M26_21_g 0.01
R_N007_21_M26_21_s N007_21 N007_21_M26_21_s 0.01
R_VDD_M26_21_b VDD VDD_M26_21_b 0.01
M26_21 N002_21_M26_21_d N005_21_M26_21_g N007_21_M26_21_s VDD_M26_21_b pmos l=1u w=4u
R_VDD_M27_21_d VDD VDD_M27_21_d 0.01
R_N007_21_M27_21_g N007_21 N007_21_M27_21_g 0.01
R_S_21_M27_21_s S_21 S_21_M27_21_s 0.01
R_VDD_M27_21_b VDD VDD_M27_21_b 0.01
M27_21 VDD_M27_21_d N007_21_M27_21_g S_21_M27_21_s VDD_M27_21_b pmos l=1u w=2u
R_S_21_M28_21_d S_21 S_21_M28_21_d 0.01
R_N007_21_M28_21_g N007_21 N007_21_M28_21_g 0.01
M28_21 S_21_M28_21_d N007_21_M28_21_g 0 0 nmos l=1u w=1u
C_S_21 S_21 0 1f
* --- Bit 22 ---
R_VDD_M1_22_d VDD VDD_M1_22_d 0.01
R_A_22_M1_22_g A_22 A_22_M1_22_g 0.01
R_N003_22_M1_22_s N003_22 N003_22_M1_22_s 0.01
R_VDD_M1_22_b VDD VDD_M1_22_b 0.01
M1_22 VDD_M1_22_d A_22_M1_22_g N003_22_M1_22_s VDD_M1_22_b pmos l=1u w=4u
R_N003_22_M2_22_d N003_22 N003_22_M2_22_d 0.01
R_B_22_M2_22_g B_22 B_22_M2_22_g 0.01
R_N005_22_M2_22_s N005_22 N005_22_M2_22_s 0.01
R_VDD_M2_22_b VDD VDD_M2_22_b 0.01
M2_22 N003_22_M2_22_d B_22_M2_22_g N005_22_M2_22_s VDD_M2_22_b pmos l=1u w=4u
R_VDD_M3_22_d VDD VDD_M3_22_d 0.01
R_A_22_M3_22_g A_22 A_22_M3_22_g 0.01
R_N001_22_M3_22_s N001_22 N001_22_M3_22_s 0.01
R_VDD_M3_22_b VDD VDD_M3_22_b 0.01
M3_22 VDD_M3_22_d A_22_M3_22_g N001_22_M3_22_s VDD_M3_22_b pmos l=1u w=4u
R_N001_22_M4_22_d N001_22 N001_22_M4_22_d 0.01
R_C_22_M4_22_g C_22 C_22_M4_22_g 0.01
R_N005_22_M4_22_s N005_22 N005_22_M4_22_s 0.01
R_VDD_M4_22_b VDD VDD_M4_22_b 0.01
M4_22 N001_22_M4_22_d C_22_M4_22_g N005_22_M4_22_s VDD_M4_22_b pmos l=1u w=4u
R_VDD_M5_22_d VDD VDD_M5_22_d 0.01
R_B_22_M5_22_g B_22 B_22_M5_22_g 0.01
R_N001_22_M5_22_s N001_22 N001_22_M5_22_s 0.01
R_VDD_M5_22_b VDD VDD_M5_22_b 0.01
M5_22 VDD_M5_22_d B_22_M5_22_g N001_22_M5_22_s VDD_M5_22_b pmos l=1u w=4u
R_VDD_M6_22_d VDD VDD_M6_22_d 0.01
R_N005_22_M6_22_g N005_22 N005_22_M6_22_g 0.01
R_C_23_M6_22_s C_23 C_23_M6_22_s 0.01
R_VDD_M6_22_b VDD VDD_M6_22_b 0.01
M6_22 VDD_M6_22_d N005_22_M6_22_g C_23_M6_22_s VDD_M6_22_b pmos l=1u w=2u
R_VDD_M7_22_d VDD VDD_M7_22_d 0.01
R_A_22_M7_22_g A_22 A_22_M7_22_g 0.01
R_N002_22_M7_22_s N002_22 N002_22_M7_22_s 0.01
R_VDD_M7_22_b VDD VDD_M7_22_b 0.01
M7_22 VDD_M7_22_d A_22_M7_22_g N002_22_M7_22_s VDD_M7_22_b pmos l=1u w=4u
R_VDD_M8_22_d VDD VDD_M8_22_d 0.01
R_B_22_M8_22_g B_22 B_22_M8_22_g 0.01
R_N002_22_M8_22_s N002_22 N002_22_M8_22_s 0.01
R_VDD_M8_22_b VDD VDD_M8_22_b 0.01
M8_22 VDD_M8_22_d B_22_M8_22_g N002_22_M8_22_s VDD_M8_22_b pmos l=1u w=4u
R_VDD_M9_22_d VDD VDD_M9_22_d 0.01
R_C_22_M9_22_g C_22 C_22_M9_22_g 0.01
R_N002_22_M9_22_s N002_22 N002_22_M9_22_s 0.01
R_VDD_M9_22_b VDD VDD_M9_22_b 0.01
M9_22 VDD_M9_22_d C_22_M9_22_g N002_22_M9_22_s VDD_M9_22_b pmos l=1u w=4u
R_VDD_M10_22_d VDD VDD_M10_22_d 0.01
R_A_22_M10_22_g A_22 A_22_M10_22_g 0.01
R_N004_22_M10_22_s N004_22 N004_22_M10_22_s 0.01
R_VDD_M10_22_b VDD VDD_M10_22_b 0.01
M10_22 VDD_M10_22_d A_22_M10_22_g N004_22_M10_22_s VDD_M10_22_b pmos l=1u w=8u
R_N004_22_M11_22_d N004_22 N004_22_M11_22_d 0.01
R_B_22_M11_22_g B_22 B_22_M11_22_g 0.01
R_N006_22_M11_22_s N006_22 N006_22_M11_22_s 0.01
R_VDD_M11_22_b VDD VDD_M11_22_b 0.01
M11_22 N004_22_M11_22_d B_22_M11_22_g N006_22_M11_22_s VDD_M11_22_b pmos l=1u w=8u
R_N006_22_M12_22_d N006_22 N006_22_M12_22_d 0.01
R_C_22_M12_22_g C_22 C_22_M12_22_g 0.01
R_N007_22_M12_22_s N007_22 N007_22_M12_22_s 0.01
R_VDD_M12_22_b VDD VDD_M12_22_b 0.01
M12_22 N006_22_M12_22_d C_22_M12_22_g N007_22_M12_22_s VDD_M12_22_b pmos l=1u w=8u
R_N007_22_M13_22_d N007_22 N007_22_M13_22_d 0.01
R_C_22_M13_22_g C_22 C_22_M13_22_g 0.01
R_N008_22_M13_22_s N008_22 N008_22_M13_22_s 0.01
M13_22 N007_22_M13_22_d C_22_M13_22_g N008_22_M13_22_s 0 nmos l=1u w=8u
R_N008_22_M14_22_d N008_22 N008_22_M14_22_d 0.01
R_B_22_M14_22_g B_22 B_22_M14_22_g 0.01
R_N012_22_M14_22_s N012_22 N012_22_M14_22_s 0.01
M14_22 N008_22_M14_22_d B_22_M14_22_g N012_22_M14_22_s 0 nmos l=1u w=8u
R_N012_22_M15_22_d N012_22 N012_22_M15_22_d 0.01
R_A_22_M15_22_g A_22 A_22_M15_22_g 0.01
M15_22 N012_22_M15_22_d A_22_M15_22_g 0 0 nmos l=1u w=8u
R_N010_22_M16_22_d N010_22 N010_22_M16_22_d 0.01
R_C_22_M16_22_g C_22 C_22_M16_22_g 0.01
M16_22 N010_22_M16_22_d C_22_M16_22_g 0 0 nmos l=1u w=2u
R_N010_22_M17_22_d N010_22 N010_22_M17_22_d 0.01
R_B_22_M17_22_g B_22 B_22_M17_22_g 0.01
M17_22 N010_22_M17_22_d B_22_M17_22_g 0 0 nmos l=1u w=2u
R_N010_22_M18_22_d N010_22 N010_22_M18_22_d 0.01
R_A_22_M18_22_g A_22 A_22_M18_22_g 0.01
M18_22 N010_22_M18_22_d A_22_M18_22_g 0 0 nmos l=1u w=2u
R_N007_22_M19_22_d N007_22 N007_22_M19_22_d 0.01
R_N005_22_M19_22_g N005_22 N005_22_M19_22_g 0.01
R_N010_22_M19_22_s N010_22 N010_22_M19_22_s 0.01
M19_22 N007_22_M19_22_d N005_22_M19_22_g N010_22_M19_22_s 0 nmos l=1u w=2u
R_N009_22_M20_22_d N009_22 N009_22_M20_22_d 0.01
R_B_22_M20_22_g B_22 B_22_M20_22_g 0.01
M20_22 N009_22_M20_22_d B_22_M20_22_g 0 0 nmos l=1u w=2u
R_N009_22_M21_22_d N009_22 N009_22_M21_22_d 0.01
R_A_22_M21_22_g A_22 A_22_M21_22_g 0.01
M21_22 N009_22_M21_22_d A_22_M21_22_g 0 0 nmos l=1u w=2u
R_N011_22_M22_22_d N011_22 N011_22_M22_22_d 0.01
R_A_22_M22_22_g A_22 A_22_M22_22_g 0.01
M22_22 N011_22_M22_22_d A_22_M22_22_g 0 0 nmos l=1u w=2u
R_N005_22_M23_22_d N005_22 N005_22_M23_22_d 0.01
R_B_22_M23_22_g B_22 B_22_M23_22_g 0.01
R_N011_22_M23_22_s N011_22 N011_22_M23_22_s 0.01
M23_22 N005_22_M23_22_d B_22_M23_22_g N011_22_M23_22_s 0 nmos l=1u w=2u
R_N005_22_M24_22_d N005_22 N005_22_M24_22_d 0.01
R_C_22_M24_22_g C_22 C_22_M24_22_g 0.01
R_N009_22_M24_22_s N009_22 N009_22_M24_22_s 0.01
M24_22 N005_22_M24_22_d C_22_M24_22_g N009_22_M24_22_s 0 nmos l=1u w=2u
R_C_23_M25_22_d C_23 C_23_M25_22_d 0.01
R_N005_22_M25_22_g N005_22 N005_22_M25_22_g 0.01
M25_22 C_23_M25_22_d N005_22_M25_22_g 0 0 nmos l=1u w=1u
R_N002_22_M26_22_d N002_22 N002_22_M26_22_d 0.01
R_N005_22_M26_22_g N005_22 N005_22_M26_22_g 0.01
R_N007_22_M26_22_s N007_22 N007_22_M26_22_s 0.01
R_VDD_M26_22_b VDD VDD_M26_22_b 0.01
M26_22 N002_22_M26_22_d N005_22_M26_22_g N007_22_M26_22_s VDD_M26_22_b pmos l=1u w=4u
R_VDD_M27_22_d VDD VDD_M27_22_d 0.01
R_N007_22_M27_22_g N007_22 N007_22_M27_22_g 0.01
R_S_22_M27_22_s S_22 S_22_M27_22_s 0.01
R_VDD_M27_22_b VDD VDD_M27_22_b 0.01
M27_22 VDD_M27_22_d N007_22_M27_22_g S_22_M27_22_s VDD_M27_22_b pmos l=1u w=2u
R_S_22_M28_22_d S_22 S_22_M28_22_d 0.01
R_N007_22_M28_22_g N007_22 N007_22_M28_22_g 0.01
M28_22 S_22_M28_22_d N007_22_M28_22_g 0 0 nmos l=1u w=1u
C_S_22 S_22 0 1f
* --- Bit 23 ---
R_VDD_M1_23_d VDD VDD_M1_23_d 0.01
R_A_23_M1_23_g A_23 A_23_M1_23_g 0.01
R_N003_23_M1_23_s N003_23 N003_23_M1_23_s 0.01
R_VDD_M1_23_b VDD VDD_M1_23_b 0.01
M1_23 VDD_M1_23_d A_23_M1_23_g N003_23_M1_23_s VDD_M1_23_b pmos l=1u w=4u
R_N003_23_M2_23_d N003_23 N003_23_M2_23_d 0.01
R_B_23_M2_23_g B_23 B_23_M2_23_g 0.01
R_N005_23_M2_23_s N005_23 N005_23_M2_23_s 0.01
R_VDD_M2_23_b VDD VDD_M2_23_b 0.01
M2_23 N003_23_M2_23_d B_23_M2_23_g N005_23_M2_23_s VDD_M2_23_b pmos l=1u w=4u
R_VDD_M3_23_d VDD VDD_M3_23_d 0.01
R_A_23_M3_23_g A_23 A_23_M3_23_g 0.01
R_N001_23_M3_23_s N001_23 N001_23_M3_23_s 0.01
R_VDD_M3_23_b VDD VDD_M3_23_b 0.01
M3_23 VDD_M3_23_d A_23_M3_23_g N001_23_M3_23_s VDD_M3_23_b pmos l=1u w=4u
R_N001_23_M4_23_d N001_23 N001_23_M4_23_d 0.01
R_C_23_M4_23_g C_23 C_23_M4_23_g 0.01
R_N005_23_M4_23_s N005_23 N005_23_M4_23_s 0.01
R_VDD_M4_23_b VDD VDD_M4_23_b 0.01
M4_23 N001_23_M4_23_d C_23_M4_23_g N005_23_M4_23_s VDD_M4_23_b pmos l=1u w=4u
R_VDD_M5_23_d VDD VDD_M5_23_d 0.01
R_B_23_M5_23_g B_23 B_23_M5_23_g 0.01
R_N001_23_M5_23_s N001_23 N001_23_M5_23_s 0.01
R_VDD_M5_23_b VDD VDD_M5_23_b 0.01
M5_23 VDD_M5_23_d B_23_M5_23_g N001_23_M5_23_s VDD_M5_23_b pmos l=1u w=4u
R_VDD_M6_23_d VDD VDD_M6_23_d 0.01
R_N005_23_M6_23_g N005_23 N005_23_M6_23_g 0.01
R_C_24_M6_23_s C_24 C_24_M6_23_s 0.01
R_VDD_M6_23_b VDD VDD_M6_23_b 0.01
M6_23 VDD_M6_23_d N005_23_M6_23_g C_24_M6_23_s VDD_M6_23_b pmos l=1u w=2u
R_VDD_M7_23_d VDD VDD_M7_23_d 0.01
R_A_23_M7_23_g A_23 A_23_M7_23_g 0.01
R_N002_23_M7_23_s N002_23 N002_23_M7_23_s 0.01
R_VDD_M7_23_b VDD VDD_M7_23_b 0.01
M7_23 VDD_M7_23_d A_23_M7_23_g N002_23_M7_23_s VDD_M7_23_b pmos l=1u w=4u
R_VDD_M8_23_d VDD VDD_M8_23_d 0.01
R_B_23_M8_23_g B_23 B_23_M8_23_g 0.01
R_N002_23_M8_23_s N002_23 N002_23_M8_23_s 0.01
R_VDD_M8_23_b VDD VDD_M8_23_b 0.01
M8_23 VDD_M8_23_d B_23_M8_23_g N002_23_M8_23_s VDD_M8_23_b pmos l=1u w=4u
R_VDD_M9_23_d VDD VDD_M9_23_d 0.01
R_C_23_M9_23_g C_23 C_23_M9_23_g 0.01
R_N002_23_M9_23_s N002_23 N002_23_M9_23_s 0.01
R_VDD_M9_23_b VDD VDD_M9_23_b 0.01
M9_23 VDD_M9_23_d C_23_M9_23_g N002_23_M9_23_s VDD_M9_23_b pmos l=1u w=4u
R_VDD_M10_23_d VDD VDD_M10_23_d 0.01
R_A_23_M10_23_g A_23 A_23_M10_23_g 0.01
R_N004_23_M10_23_s N004_23 N004_23_M10_23_s 0.01
R_VDD_M10_23_b VDD VDD_M10_23_b 0.01
M10_23 VDD_M10_23_d A_23_M10_23_g N004_23_M10_23_s VDD_M10_23_b pmos l=1u w=8u
R_N004_23_M11_23_d N004_23 N004_23_M11_23_d 0.01
R_B_23_M11_23_g B_23 B_23_M11_23_g 0.01
R_N006_23_M11_23_s N006_23 N006_23_M11_23_s 0.01
R_VDD_M11_23_b VDD VDD_M11_23_b 0.01
M11_23 N004_23_M11_23_d B_23_M11_23_g N006_23_M11_23_s VDD_M11_23_b pmos l=1u w=8u
R_N006_23_M12_23_d N006_23 N006_23_M12_23_d 0.01
R_C_23_M12_23_g C_23 C_23_M12_23_g 0.01
R_N007_23_M12_23_s N007_23 N007_23_M12_23_s 0.01
R_VDD_M12_23_b VDD VDD_M12_23_b 0.01
M12_23 N006_23_M12_23_d C_23_M12_23_g N007_23_M12_23_s VDD_M12_23_b pmos l=1u w=8u
R_N007_23_M13_23_d N007_23 N007_23_M13_23_d 0.01
R_C_23_M13_23_g C_23 C_23_M13_23_g 0.01
R_N008_23_M13_23_s N008_23 N008_23_M13_23_s 0.01
M13_23 N007_23_M13_23_d C_23_M13_23_g N008_23_M13_23_s 0 nmos l=1u w=8u
R_N008_23_M14_23_d N008_23 N008_23_M14_23_d 0.01
R_B_23_M14_23_g B_23 B_23_M14_23_g 0.01
R_N012_23_M14_23_s N012_23 N012_23_M14_23_s 0.01
M14_23 N008_23_M14_23_d B_23_M14_23_g N012_23_M14_23_s 0 nmos l=1u w=8u
R_N012_23_M15_23_d N012_23 N012_23_M15_23_d 0.01
R_A_23_M15_23_g A_23 A_23_M15_23_g 0.01
M15_23 N012_23_M15_23_d A_23_M15_23_g 0 0 nmos l=1u w=8u
R_N010_23_M16_23_d N010_23 N010_23_M16_23_d 0.01
R_C_23_M16_23_g C_23 C_23_M16_23_g 0.01
M16_23 N010_23_M16_23_d C_23_M16_23_g 0 0 nmos l=1u w=2u
R_N010_23_M17_23_d N010_23 N010_23_M17_23_d 0.01
R_B_23_M17_23_g B_23 B_23_M17_23_g 0.01
M17_23 N010_23_M17_23_d B_23_M17_23_g 0 0 nmos l=1u w=2u
R_N010_23_M18_23_d N010_23 N010_23_M18_23_d 0.01
R_A_23_M18_23_g A_23 A_23_M18_23_g 0.01
M18_23 N010_23_M18_23_d A_23_M18_23_g 0 0 nmos l=1u w=2u
R_N007_23_M19_23_d N007_23 N007_23_M19_23_d 0.01
R_N005_23_M19_23_g N005_23 N005_23_M19_23_g 0.01
R_N010_23_M19_23_s N010_23 N010_23_M19_23_s 0.01
M19_23 N007_23_M19_23_d N005_23_M19_23_g N010_23_M19_23_s 0 nmos l=1u w=2u
R_N009_23_M20_23_d N009_23 N009_23_M20_23_d 0.01
R_B_23_M20_23_g B_23 B_23_M20_23_g 0.01
M20_23 N009_23_M20_23_d B_23_M20_23_g 0 0 nmos l=1u w=2u
R_N009_23_M21_23_d N009_23 N009_23_M21_23_d 0.01
R_A_23_M21_23_g A_23 A_23_M21_23_g 0.01
M21_23 N009_23_M21_23_d A_23_M21_23_g 0 0 nmos l=1u w=2u
R_N011_23_M22_23_d N011_23 N011_23_M22_23_d 0.01
R_A_23_M22_23_g A_23 A_23_M22_23_g 0.01
M22_23 N011_23_M22_23_d A_23_M22_23_g 0 0 nmos l=1u w=2u
R_N005_23_M23_23_d N005_23 N005_23_M23_23_d 0.01
R_B_23_M23_23_g B_23 B_23_M23_23_g 0.01
R_N011_23_M23_23_s N011_23 N011_23_M23_23_s 0.01
M23_23 N005_23_M23_23_d B_23_M23_23_g N011_23_M23_23_s 0 nmos l=1u w=2u
R_N005_23_M24_23_d N005_23 N005_23_M24_23_d 0.01
R_C_23_M24_23_g C_23 C_23_M24_23_g 0.01
R_N009_23_M24_23_s N009_23 N009_23_M24_23_s 0.01
M24_23 N005_23_M24_23_d C_23_M24_23_g N009_23_M24_23_s 0 nmos l=1u w=2u
R_C_24_M25_23_d C_24 C_24_M25_23_d 0.01
R_N005_23_M25_23_g N005_23 N005_23_M25_23_g 0.01
M25_23 C_24_M25_23_d N005_23_M25_23_g 0 0 nmos l=1u w=1u
R_N002_23_M26_23_d N002_23 N002_23_M26_23_d 0.01
R_N005_23_M26_23_g N005_23 N005_23_M26_23_g 0.01
R_N007_23_M26_23_s N007_23 N007_23_M26_23_s 0.01
R_VDD_M26_23_b VDD VDD_M26_23_b 0.01
M26_23 N002_23_M26_23_d N005_23_M26_23_g N007_23_M26_23_s VDD_M26_23_b pmos l=1u w=4u
R_VDD_M27_23_d VDD VDD_M27_23_d 0.01
R_N007_23_M27_23_g N007_23 N007_23_M27_23_g 0.01
R_S_23_M27_23_s S_23 S_23_M27_23_s 0.01
R_VDD_M27_23_b VDD VDD_M27_23_b 0.01
M27_23 VDD_M27_23_d N007_23_M27_23_g S_23_M27_23_s VDD_M27_23_b pmos l=1u w=2u
R_S_23_M28_23_d S_23 S_23_M28_23_d 0.01
R_N007_23_M28_23_g N007_23 N007_23_M28_23_g 0.01
M28_23 S_23_M28_23_d N007_23_M28_23_g 0 0 nmos l=1u w=1u
C_S_23 S_23 0 1f
* --- Bit 24 ---
R_VDD_M1_24_d VDD VDD_M1_24_d 0.01
R_A_24_M1_24_g A_24 A_24_M1_24_g 0.01
R_N003_24_M1_24_s N003_24 N003_24_M1_24_s 0.01
R_VDD_M1_24_b VDD VDD_M1_24_b 0.01
M1_24 VDD_M1_24_d A_24_M1_24_g N003_24_M1_24_s VDD_M1_24_b pmos l=1u w=4u
R_N003_24_M2_24_d N003_24 N003_24_M2_24_d 0.01
R_B_24_M2_24_g B_24 B_24_M2_24_g 0.01
R_N005_24_M2_24_s N005_24 N005_24_M2_24_s 0.01
R_VDD_M2_24_b VDD VDD_M2_24_b 0.01
M2_24 N003_24_M2_24_d B_24_M2_24_g N005_24_M2_24_s VDD_M2_24_b pmos l=1u w=4u
R_VDD_M3_24_d VDD VDD_M3_24_d 0.01
R_A_24_M3_24_g A_24 A_24_M3_24_g 0.01
R_N001_24_M3_24_s N001_24 N001_24_M3_24_s 0.01
R_VDD_M3_24_b VDD VDD_M3_24_b 0.01
M3_24 VDD_M3_24_d A_24_M3_24_g N001_24_M3_24_s VDD_M3_24_b pmos l=1u w=4u
R_N001_24_M4_24_d N001_24 N001_24_M4_24_d 0.01
R_C_24_M4_24_g C_24 C_24_M4_24_g 0.01
R_N005_24_M4_24_s N005_24 N005_24_M4_24_s 0.01
R_VDD_M4_24_b VDD VDD_M4_24_b 0.01
M4_24 N001_24_M4_24_d C_24_M4_24_g N005_24_M4_24_s VDD_M4_24_b pmos l=1u w=4u
R_VDD_M5_24_d VDD VDD_M5_24_d 0.01
R_B_24_M5_24_g B_24 B_24_M5_24_g 0.01
R_N001_24_M5_24_s N001_24 N001_24_M5_24_s 0.01
R_VDD_M5_24_b VDD VDD_M5_24_b 0.01
M5_24 VDD_M5_24_d B_24_M5_24_g N001_24_M5_24_s VDD_M5_24_b pmos l=1u w=4u
R_VDD_M6_24_d VDD VDD_M6_24_d 0.01
R_N005_24_M6_24_g N005_24 N005_24_M6_24_g 0.01
R_C_25_M6_24_s C_25 C_25_M6_24_s 0.01
R_VDD_M6_24_b VDD VDD_M6_24_b 0.01
M6_24 VDD_M6_24_d N005_24_M6_24_g C_25_M6_24_s VDD_M6_24_b pmos l=1u w=2u
R_VDD_M7_24_d VDD VDD_M7_24_d 0.01
R_A_24_M7_24_g A_24 A_24_M7_24_g 0.01
R_N002_24_M7_24_s N002_24 N002_24_M7_24_s 0.01
R_VDD_M7_24_b VDD VDD_M7_24_b 0.01
M7_24 VDD_M7_24_d A_24_M7_24_g N002_24_M7_24_s VDD_M7_24_b pmos l=1u w=4u
R_VDD_M8_24_d VDD VDD_M8_24_d 0.01
R_B_24_M8_24_g B_24 B_24_M8_24_g 0.01
R_N002_24_M8_24_s N002_24 N002_24_M8_24_s 0.01
R_VDD_M8_24_b VDD VDD_M8_24_b 0.01
M8_24 VDD_M8_24_d B_24_M8_24_g N002_24_M8_24_s VDD_M8_24_b pmos l=1u w=4u
R_VDD_M9_24_d VDD VDD_M9_24_d 0.01
R_C_24_M9_24_g C_24 C_24_M9_24_g 0.01
R_N002_24_M9_24_s N002_24 N002_24_M9_24_s 0.01
R_VDD_M9_24_b VDD VDD_M9_24_b 0.01
M9_24 VDD_M9_24_d C_24_M9_24_g N002_24_M9_24_s VDD_M9_24_b pmos l=1u w=4u
R_VDD_M10_24_d VDD VDD_M10_24_d 0.01
R_A_24_M10_24_g A_24 A_24_M10_24_g 0.01
R_N004_24_M10_24_s N004_24 N004_24_M10_24_s 0.01
R_VDD_M10_24_b VDD VDD_M10_24_b 0.01
M10_24 VDD_M10_24_d A_24_M10_24_g N004_24_M10_24_s VDD_M10_24_b pmos l=1u w=8u
R_N004_24_M11_24_d N004_24 N004_24_M11_24_d 0.01
R_B_24_M11_24_g B_24 B_24_M11_24_g 0.01
R_N006_24_M11_24_s N006_24 N006_24_M11_24_s 0.01
R_VDD_M11_24_b VDD VDD_M11_24_b 0.01
M11_24 N004_24_M11_24_d B_24_M11_24_g N006_24_M11_24_s VDD_M11_24_b pmos l=1u w=8u
R_N006_24_M12_24_d N006_24 N006_24_M12_24_d 0.01
R_C_24_M12_24_g C_24 C_24_M12_24_g 0.01
R_N007_24_M12_24_s N007_24 N007_24_M12_24_s 0.01
R_VDD_M12_24_b VDD VDD_M12_24_b 0.01
M12_24 N006_24_M12_24_d C_24_M12_24_g N007_24_M12_24_s VDD_M12_24_b pmos l=1u w=8u
R_N007_24_M13_24_d N007_24 N007_24_M13_24_d 0.01
R_C_24_M13_24_g C_24 C_24_M13_24_g 0.01
R_N008_24_M13_24_s N008_24 N008_24_M13_24_s 0.01
M13_24 N007_24_M13_24_d C_24_M13_24_g N008_24_M13_24_s 0 nmos l=1u w=8u
R_N008_24_M14_24_d N008_24 N008_24_M14_24_d 0.01
R_B_24_M14_24_g B_24 B_24_M14_24_g 0.01
R_N012_24_M14_24_s N012_24 N012_24_M14_24_s 0.01
M14_24 N008_24_M14_24_d B_24_M14_24_g N012_24_M14_24_s 0 nmos l=1u w=8u
R_N012_24_M15_24_d N012_24 N012_24_M15_24_d 0.01
R_A_24_M15_24_g A_24 A_24_M15_24_g 0.01
M15_24 N012_24_M15_24_d A_24_M15_24_g 0 0 nmos l=1u w=8u
R_N010_24_M16_24_d N010_24 N010_24_M16_24_d 0.01
R_C_24_M16_24_g C_24 C_24_M16_24_g 0.01
M16_24 N010_24_M16_24_d C_24_M16_24_g 0 0 nmos l=1u w=2u
R_N010_24_M17_24_d N010_24 N010_24_M17_24_d 0.01
R_B_24_M17_24_g B_24 B_24_M17_24_g 0.01
M17_24 N010_24_M17_24_d B_24_M17_24_g 0 0 nmos l=1u w=2u
R_N010_24_M18_24_d N010_24 N010_24_M18_24_d 0.01
R_A_24_M18_24_g A_24 A_24_M18_24_g 0.01
M18_24 N010_24_M18_24_d A_24_M18_24_g 0 0 nmos l=1u w=2u
R_N007_24_M19_24_d N007_24 N007_24_M19_24_d 0.01
R_N005_24_M19_24_g N005_24 N005_24_M19_24_g 0.01
R_N010_24_M19_24_s N010_24 N010_24_M19_24_s 0.01
M19_24 N007_24_M19_24_d N005_24_M19_24_g N010_24_M19_24_s 0 nmos l=1u w=2u
R_N009_24_M20_24_d N009_24 N009_24_M20_24_d 0.01
R_B_24_M20_24_g B_24 B_24_M20_24_g 0.01
M20_24 N009_24_M20_24_d B_24_M20_24_g 0 0 nmos l=1u w=2u
R_N009_24_M21_24_d N009_24 N009_24_M21_24_d 0.01
R_A_24_M21_24_g A_24 A_24_M21_24_g 0.01
M21_24 N009_24_M21_24_d A_24_M21_24_g 0 0 nmos l=1u w=2u
R_N011_24_M22_24_d N011_24 N011_24_M22_24_d 0.01
R_A_24_M22_24_g A_24 A_24_M22_24_g 0.01
M22_24 N011_24_M22_24_d A_24_M22_24_g 0 0 nmos l=1u w=2u
R_N005_24_M23_24_d N005_24 N005_24_M23_24_d 0.01
R_B_24_M23_24_g B_24 B_24_M23_24_g 0.01
R_N011_24_M23_24_s N011_24 N011_24_M23_24_s 0.01
M23_24 N005_24_M23_24_d B_24_M23_24_g N011_24_M23_24_s 0 nmos l=1u w=2u
R_N005_24_M24_24_d N005_24 N005_24_M24_24_d 0.01
R_C_24_M24_24_g C_24 C_24_M24_24_g 0.01
R_N009_24_M24_24_s N009_24 N009_24_M24_24_s 0.01
M24_24 N005_24_M24_24_d C_24_M24_24_g N009_24_M24_24_s 0 nmos l=1u w=2u
R_C_25_M25_24_d C_25 C_25_M25_24_d 0.01
R_N005_24_M25_24_g N005_24 N005_24_M25_24_g 0.01
M25_24 C_25_M25_24_d N005_24_M25_24_g 0 0 nmos l=1u w=1u
R_N002_24_M26_24_d N002_24 N002_24_M26_24_d 0.01
R_N005_24_M26_24_g N005_24 N005_24_M26_24_g 0.01
R_N007_24_M26_24_s N007_24 N007_24_M26_24_s 0.01
R_VDD_M26_24_b VDD VDD_M26_24_b 0.01
M26_24 N002_24_M26_24_d N005_24_M26_24_g N007_24_M26_24_s VDD_M26_24_b pmos l=1u w=4u
R_VDD_M27_24_d VDD VDD_M27_24_d 0.01
R_N007_24_M27_24_g N007_24 N007_24_M27_24_g 0.01
R_S_24_M27_24_s S_24 S_24_M27_24_s 0.01
R_VDD_M27_24_b VDD VDD_M27_24_b 0.01
M27_24 VDD_M27_24_d N007_24_M27_24_g S_24_M27_24_s VDD_M27_24_b pmos l=1u w=2u
R_S_24_M28_24_d S_24 S_24_M28_24_d 0.01
R_N007_24_M28_24_g N007_24 N007_24_M28_24_g 0.01
M28_24 S_24_M28_24_d N007_24_M28_24_g 0 0 nmos l=1u w=1u
C_S_24 S_24 0 1f
* --- Bit 25 ---
R_VDD_M1_25_d VDD VDD_M1_25_d 0.01
R_A_25_M1_25_g A_25 A_25_M1_25_g 0.01
R_N003_25_M1_25_s N003_25 N003_25_M1_25_s 0.01
R_VDD_M1_25_b VDD VDD_M1_25_b 0.01
M1_25 VDD_M1_25_d A_25_M1_25_g N003_25_M1_25_s VDD_M1_25_b pmos l=1u w=4u
R_N003_25_M2_25_d N003_25 N003_25_M2_25_d 0.01
R_B_25_M2_25_g B_25 B_25_M2_25_g 0.01
R_N005_25_M2_25_s N005_25 N005_25_M2_25_s 0.01
R_VDD_M2_25_b VDD VDD_M2_25_b 0.01
M2_25 N003_25_M2_25_d B_25_M2_25_g N005_25_M2_25_s VDD_M2_25_b pmos l=1u w=4u
R_VDD_M3_25_d VDD VDD_M3_25_d 0.01
R_A_25_M3_25_g A_25 A_25_M3_25_g 0.01
R_N001_25_M3_25_s N001_25 N001_25_M3_25_s 0.01
R_VDD_M3_25_b VDD VDD_M3_25_b 0.01
M3_25 VDD_M3_25_d A_25_M3_25_g N001_25_M3_25_s VDD_M3_25_b pmos l=1u w=4u
R_N001_25_M4_25_d N001_25 N001_25_M4_25_d 0.01
R_C_25_M4_25_g C_25 C_25_M4_25_g 0.01
R_N005_25_M4_25_s N005_25 N005_25_M4_25_s 0.01
R_VDD_M4_25_b VDD VDD_M4_25_b 0.01
M4_25 N001_25_M4_25_d C_25_M4_25_g N005_25_M4_25_s VDD_M4_25_b pmos l=1u w=4u
R_VDD_M5_25_d VDD VDD_M5_25_d 0.01
R_B_25_M5_25_g B_25 B_25_M5_25_g 0.01
R_N001_25_M5_25_s N001_25 N001_25_M5_25_s 0.01
R_VDD_M5_25_b VDD VDD_M5_25_b 0.01
M5_25 VDD_M5_25_d B_25_M5_25_g N001_25_M5_25_s VDD_M5_25_b pmos l=1u w=4u
R_VDD_M6_25_d VDD VDD_M6_25_d 0.01
R_N005_25_M6_25_g N005_25 N005_25_M6_25_g 0.01
R_C_26_M6_25_s C_26 C_26_M6_25_s 0.01
R_VDD_M6_25_b VDD VDD_M6_25_b 0.01
M6_25 VDD_M6_25_d N005_25_M6_25_g C_26_M6_25_s VDD_M6_25_b pmos l=1u w=2u
R_VDD_M7_25_d VDD VDD_M7_25_d 0.01
R_A_25_M7_25_g A_25 A_25_M7_25_g 0.01
R_N002_25_M7_25_s N002_25 N002_25_M7_25_s 0.01
R_VDD_M7_25_b VDD VDD_M7_25_b 0.01
M7_25 VDD_M7_25_d A_25_M7_25_g N002_25_M7_25_s VDD_M7_25_b pmos l=1u w=4u
R_VDD_M8_25_d VDD VDD_M8_25_d 0.01
R_B_25_M8_25_g B_25 B_25_M8_25_g 0.01
R_N002_25_M8_25_s N002_25 N002_25_M8_25_s 0.01
R_VDD_M8_25_b VDD VDD_M8_25_b 0.01
M8_25 VDD_M8_25_d B_25_M8_25_g N002_25_M8_25_s VDD_M8_25_b pmos l=1u w=4u
R_VDD_M9_25_d VDD VDD_M9_25_d 0.01
R_C_25_M9_25_g C_25 C_25_M9_25_g 0.01
R_N002_25_M9_25_s N002_25 N002_25_M9_25_s 0.01
R_VDD_M9_25_b VDD VDD_M9_25_b 0.01
M9_25 VDD_M9_25_d C_25_M9_25_g N002_25_M9_25_s VDD_M9_25_b pmos l=1u w=4u
R_VDD_M10_25_d VDD VDD_M10_25_d 0.01
R_A_25_M10_25_g A_25 A_25_M10_25_g 0.01
R_N004_25_M10_25_s N004_25 N004_25_M10_25_s 0.01
R_VDD_M10_25_b VDD VDD_M10_25_b 0.01
M10_25 VDD_M10_25_d A_25_M10_25_g N004_25_M10_25_s VDD_M10_25_b pmos l=1u w=8u
R_N004_25_M11_25_d N004_25 N004_25_M11_25_d 0.01
R_B_25_M11_25_g B_25 B_25_M11_25_g 0.01
R_N006_25_M11_25_s N006_25 N006_25_M11_25_s 0.01
R_VDD_M11_25_b VDD VDD_M11_25_b 0.01
M11_25 N004_25_M11_25_d B_25_M11_25_g N006_25_M11_25_s VDD_M11_25_b pmos l=1u w=8u
R_N006_25_M12_25_d N006_25 N006_25_M12_25_d 0.01
R_C_25_M12_25_g C_25 C_25_M12_25_g 0.01
R_N007_25_M12_25_s N007_25 N007_25_M12_25_s 0.01
R_VDD_M12_25_b VDD VDD_M12_25_b 0.01
M12_25 N006_25_M12_25_d C_25_M12_25_g N007_25_M12_25_s VDD_M12_25_b pmos l=1u w=8u
R_N007_25_M13_25_d N007_25 N007_25_M13_25_d 0.01
R_C_25_M13_25_g C_25 C_25_M13_25_g 0.01
R_N008_25_M13_25_s N008_25 N008_25_M13_25_s 0.01
M13_25 N007_25_M13_25_d C_25_M13_25_g N008_25_M13_25_s 0 nmos l=1u w=8u
R_N008_25_M14_25_d N008_25 N008_25_M14_25_d 0.01
R_B_25_M14_25_g B_25 B_25_M14_25_g 0.01
R_N012_25_M14_25_s N012_25 N012_25_M14_25_s 0.01
M14_25 N008_25_M14_25_d B_25_M14_25_g N012_25_M14_25_s 0 nmos l=1u w=8u
R_N012_25_M15_25_d N012_25 N012_25_M15_25_d 0.01
R_A_25_M15_25_g A_25 A_25_M15_25_g 0.01
M15_25 N012_25_M15_25_d A_25_M15_25_g 0 0 nmos l=1u w=8u
R_N010_25_M16_25_d N010_25 N010_25_M16_25_d 0.01
R_C_25_M16_25_g C_25 C_25_M16_25_g 0.01
M16_25 N010_25_M16_25_d C_25_M16_25_g 0 0 nmos l=1u w=2u
R_N010_25_M17_25_d N010_25 N010_25_M17_25_d 0.01
R_B_25_M17_25_g B_25 B_25_M17_25_g 0.01
M17_25 N010_25_M17_25_d B_25_M17_25_g 0 0 nmos l=1u w=2u
R_N010_25_M18_25_d N010_25 N010_25_M18_25_d 0.01
R_A_25_M18_25_g A_25 A_25_M18_25_g 0.01
M18_25 N010_25_M18_25_d A_25_M18_25_g 0 0 nmos l=1u w=2u
R_N007_25_M19_25_d N007_25 N007_25_M19_25_d 0.01
R_N005_25_M19_25_g N005_25 N005_25_M19_25_g 0.01
R_N010_25_M19_25_s N010_25 N010_25_M19_25_s 0.01
M19_25 N007_25_M19_25_d N005_25_M19_25_g N010_25_M19_25_s 0 nmos l=1u w=2u
R_N009_25_M20_25_d N009_25 N009_25_M20_25_d 0.01
R_B_25_M20_25_g B_25 B_25_M20_25_g 0.01
M20_25 N009_25_M20_25_d B_25_M20_25_g 0 0 nmos l=1u w=2u
R_N009_25_M21_25_d N009_25 N009_25_M21_25_d 0.01
R_A_25_M21_25_g A_25 A_25_M21_25_g 0.01
M21_25 N009_25_M21_25_d A_25_M21_25_g 0 0 nmos l=1u w=2u
R_N011_25_M22_25_d N011_25 N011_25_M22_25_d 0.01
R_A_25_M22_25_g A_25 A_25_M22_25_g 0.01
M22_25 N011_25_M22_25_d A_25_M22_25_g 0 0 nmos l=1u w=2u
R_N005_25_M23_25_d N005_25 N005_25_M23_25_d 0.01
R_B_25_M23_25_g B_25 B_25_M23_25_g 0.01
R_N011_25_M23_25_s N011_25 N011_25_M23_25_s 0.01
M23_25 N005_25_M23_25_d B_25_M23_25_g N011_25_M23_25_s 0 nmos l=1u w=2u
R_N005_25_M24_25_d N005_25 N005_25_M24_25_d 0.01
R_C_25_M24_25_g C_25 C_25_M24_25_g 0.01
R_N009_25_M24_25_s N009_25 N009_25_M24_25_s 0.01
M24_25 N005_25_M24_25_d C_25_M24_25_g N009_25_M24_25_s 0 nmos l=1u w=2u
R_C_26_M25_25_d C_26 C_26_M25_25_d 0.01
R_N005_25_M25_25_g N005_25 N005_25_M25_25_g 0.01
M25_25 C_26_M25_25_d N005_25_M25_25_g 0 0 nmos l=1u w=1u
R_N002_25_M26_25_d N002_25 N002_25_M26_25_d 0.01
R_N005_25_M26_25_g N005_25 N005_25_M26_25_g 0.01
R_N007_25_M26_25_s N007_25 N007_25_M26_25_s 0.01
R_VDD_M26_25_b VDD VDD_M26_25_b 0.01
M26_25 N002_25_M26_25_d N005_25_M26_25_g N007_25_M26_25_s VDD_M26_25_b pmos l=1u w=4u
R_VDD_M27_25_d VDD VDD_M27_25_d 0.01
R_N007_25_M27_25_g N007_25 N007_25_M27_25_g 0.01
R_S_25_M27_25_s S_25 S_25_M27_25_s 0.01
R_VDD_M27_25_b VDD VDD_M27_25_b 0.01
M27_25 VDD_M27_25_d N007_25_M27_25_g S_25_M27_25_s VDD_M27_25_b pmos l=1u w=2u
R_S_25_M28_25_d S_25 S_25_M28_25_d 0.01
R_N007_25_M28_25_g N007_25 N007_25_M28_25_g 0.01
M28_25 S_25_M28_25_d N007_25_M28_25_g 0 0 nmos l=1u w=1u
C_S_25 S_25 0 1f
* --- Bit 26 ---
R_VDD_M1_26_d VDD VDD_M1_26_d 0.01
R_A_26_M1_26_g A_26 A_26_M1_26_g 0.01
R_N003_26_M1_26_s N003_26 N003_26_M1_26_s 0.01
R_VDD_M1_26_b VDD VDD_M1_26_b 0.01
M1_26 VDD_M1_26_d A_26_M1_26_g N003_26_M1_26_s VDD_M1_26_b pmos l=1u w=4u
R_N003_26_M2_26_d N003_26 N003_26_M2_26_d 0.01
R_B_26_M2_26_g B_26 B_26_M2_26_g 0.01
R_N005_26_M2_26_s N005_26 N005_26_M2_26_s 0.01
R_VDD_M2_26_b VDD VDD_M2_26_b 0.01
M2_26 N003_26_M2_26_d B_26_M2_26_g N005_26_M2_26_s VDD_M2_26_b pmos l=1u w=4u
R_VDD_M3_26_d VDD VDD_M3_26_d 0.01
R_A_26_M3_26_g A_26 A_26_M3_26_g 0.01
R_N001_26_M3_26_s N001_26 N001_26_M3_26_s 0.01
R_VDD_M3_26_b VDD VDD_M3_26_b 0.01
M3_26 VDD_M3_26_d A_26_M3_26_g N001_26_M3_26_s VDD_M3_26_b pmos l=1u w=4u
R_N001_26_M4_26_d N001_26 N001_26_M4_26_d 0.01
R_C_26_M4_26_g C_26 C_26_M4_26_g 0.01
R_N005_26_M4_26_s N005_26 N005_26_M4_26_s 0.01
R_VDD_M4_26_b VDD VDD_M4_26_b 0.01
M4_26 N001_26_M4_26_d C_26_M4_26_g N005_26_M4_26_s VDD_M4_26_b pmos l=1u w=4u
R_VDD_M5_26_d VDD VDD_M5_26_d 0.01
R_B_26_M5_26_g B_26 B_26_M5_26_g 0.01
R_N001_26_M5_26_s N001_26 N001_26_M5_26_s 0.01
R_VDD_M5_26_b VDD VDD_M5_26_b 0.01
M5_26 VDD_M5_26_d B_26_M5_26_g N001_26_M5_26_s VDD_M5_26_b pmos l=1u w=4u
R_VDD_M6_26_d VDD VDD_M6_26_d 0.01
R_N005_26_M6_26_g N005_26 N005_26_M6_26_g 0.01
R_C_27_M6_26_s C_27 C_27_M6_26_s 0.01
R_VDD_M6_26_b VDD VDD_M6_26_b 0.01
M6_26 VDD_M6_26_d N005_26_M6_26_g C_27_M6_26_s VDD_M6_26_b pmos l=1u w=2u
R_VDD_M7_26_d VDD VDD_M7_26_d 0.01
R_A_26_M7_26_g A_26 A_26_M7_26_g 0.01
R_N002_26_M7_26_s N002_26 N002_26_M7_26_s 0.01
R_VDD_M7_26_b VDD VDD_M7_26_b 0.01
M7_26 VDD_M7_26_d A_26_M7_26_g N002_26_M7_26_s VDD_M7_26_b pmos l=1u w=4u
R_VDD_M8_26_d VDD VDD_M8_26_d 0.01
R_B_26_M8_26_g B_26 B_26_M8_26_g 0.01
R_N002_26_M8_26_s N002_26 N002_26_M8_26_s 0.01
R_VDD_M8_26_b VDD VDD_M8_26_b 0.01
M8_26 VDD_M8_26_d B_26_M8_26_g N002_26_M8_26_s VDD_M8_26_b pmos l=1u w=4u
R_VDD_M9_26_d VDD VDD_M9_26_d 0.01
R_C_26_M9_26_g C_26 C_26_M9_26_g 0.01
R_N002_26_M9_26_s N002_26 N002_26_M9_26_s 0.01
R_VDD_M9_26_b VDD VDD_M9_26_b 0.01
M9_26 VDD_M9_26_d C_26_M9_26_g N002_26_M9_26_s VDD_M9_26_b pmos l=1u w=4u
R_VDD_M10_26_d VDD VDD_M10_26_d 0.01
R_A_26_M10_26_g A_26 A_26_M10_26_g 0.01
R_N004_26_M10_26_s N004_26 N004_26_M10_26_s 0.01
R_VDD_M10_26_b VDD VDD_M10_26_b 0.01
M10_26 VDD_M10_26_d A_26_M10_26_g N004_26_M10_26_s VDD_M10_26_b pmos l=1u w=8u
R_N004_26_M11_26_d N004_26 N004_26_M11_26_d 0.01
R_B_26_M11_26_g B_26 B_26_M11_26_g 0.01
R_N006_26_M11_26_s N006_26 N006_26_M11_26_s 0.01
R_VDD_M11_26_b VDD VDD_M11_26_b 0.01
M11_26 N004_26_M11_26_d B_26_M11_26_g N006_26_M11_26_s VDD_M11_26_b pmos l=1u w=8u
R_N006_26_M12_26_d N006_26 N006_26_M12_26_d 0.01
R_C_26_M12_26_g C_26 C_26_M12_26_g 0.01
R_N007_26_M12_26_s N007_26 N007_26_M12_26_s 0.01
R_VDD_M12_26_b VDD VDD_M12_26_b 0.01
M12_26 N006_26_M12_26_d C_26_M12_26_g N007_26_M12_26_s VDD_M12_26_b pmos l=1u w=8u
R_N007_26_M13_26_d N007_26 N007_26_M13_26_d 0.01
R_C_26_M13_26_g C_26 C_26_M13_26_g 0.01
R_N008_26_M13_26_s N008_26 N008_26_M13_26_s 0.01
M13_26 N007_26_M13_26_d C_26_M13_26_g N008_26_M13_26_s 0 nmos l=1u w=8u
R_N008_26_M14_26_d N008_26 N008_26_M14_26_d 0.01
R_B_26_M14_26_g B_26 B_26_M14_26_g 0.01
R_N012_26_M14_26_s N012_26 N012_26_M14_26_s 0.01
M14_26 N008_26_M14_26_d B_26_M14_26_g N012_26_M14_26_s 0 nmos l=1u w=8u
R_N012_26_M15_26_d N012_26 N012_26_M15_26_d 0.01
R_A_26_M15_26_g A_26 A_26_M15_26_g 0.01
M15_26 N012_26_M15_26_d A_26_M15_26_g 0 0 nmos l=1u w=8u
R_N010_26_M16_26_d N010_26 N010_26_M16_26_d 0.01
R_C_26_M16_26_g C_26 C_26_M16_26_g 0.01
M16_26 N010_26_M16_26_d C_26_M16_26_g 0 0 nmos l=1u w=2u
R_N010_26_M17_26_d N010_26 N010_26_M17_26_d 0.01
R_B_26_M17_26_g B_26 B_26_M17_26_g 0.01
M17_26 N010_26_M17_26_d B_26_M17_26_g 0 0 nmos l=1u w=2u
R_N010_26_M18_26_d N010_26 N010_26_M18_26_d 0.01
R_A_26_M18_26_g A_26 A_26_M18_26_g 0.01
M18_26 N010_26_M18_26_d A_26_M18_26_g 0 0 nmos l=1u w=2u
R_N007_26_M19_26_d N007_26 N007_26_M19_26_d 0.01
R_N005_26_M19_26_g N005_26 N005_26_M19_26_g 0.01
R_N010_26_M19_26_s N010_26 N010_26_M19_26_s 0.01
M19_26 N007_26_M19_26_d N005_26_M19_26_g N010_26_M19_26_s 0 nmos l=1u w=2u
R_N009_26_M20_26_d N009_26 N009_26_M20_26_d 0.01
R_B_26_M20_26_g B_26 B_26_M20_26_g 0.01
M20_26 N009_26_M20_26_d B_26_M20_26_g 0 0 nmos l=1u w=2u
R_N009_26_M21_26_d N009_26 N009_26_M21_26_d 0.01
R_A_26_M21_26_g A_26 A_26_M21_26_g 0.01
M21_26 N009_26_M21_26_d A_26_M21_26_g 0 0 nmos l=1u w=2u
R_N011_26_M22_26_d N011_26 N011_26_M22_26_d 0.01
R_A_26_M22_26_g A_26 A_26_M22_26_g 0.01
M22_26 N011_26_M22_26_d A_26_M22_26_g 0 0 nmos l=1u w=2u
R_N005_26_M23_26_d N005_26 N005_26_M23_26_d 0.01
R_B_26_M23_26_g B_26 B_26_M23_26_g 0.01
R_N011_26_M23_26_s N011_26 N011_26_M23_26_s 0.01
M23_26 N005_26_M23_26_d B_26_M23_26_g N011_26_M23_26_s 0 nmos l=1u w=2u
R_N005_26_M24_26_d N005_26 N005_26_M24_26_d 0.01
R_C_26_M24_26_g C_26 C_26_M24_26_g 0.01
R_N009_26_M24_26_s N009_26 N009_26_M24_26_s 0.01
M24_26 N005_26_M24_26_d C_26_M24_26_g N009_26_M24_26_s 0 nmos l=1u w=2u
R_C_27_M25_26_d C_27 C_27_M25_26_d 0.01
R_N005_26_M25_26_g N005_26 N005_26_M25_26_g 0.01
M25_26 C_27_M25_26_d N005_26_M25_26_g 0 0 nmos l=1u w=1u
R_N002_26_M26_26_d N002_26 N002_26_M26_26_d 0.01
R_N005_26_M26_26_g N005_26 N005_26_M26_26_g 0.01
R_N007_26_M26_26_s N007_26 N007_26_M26_26_s 0.01
R_VDD_M26_26_b VDD VDD_M26_26_b 0.01
M26_26 N002_26_M26_26_d N005_26_M26_26_g N007_26_M26_26_s VDD_M26_26_b pmos l=1u w=4u
R_VDD_M27_26_d VDD VDD_M27_26_d 0.01
R_N007_26_M27_26_g N007_26 N007_26_M27_26_g 0.01
R_S_26_M27_26_s S_26 S_26_M27_26_s 0.01
R_VDD_M27_26_b VDD VDD_M27_26_b 0.01
M27_26 VDD_M27_26_d N007_26_M27_26_g S_26_M27_26_s VDD_M27_26_b pmos l=1u w=2u
R_S_26_M28_26_d S_26 S_26_M28_26_d 0.01
R_N007_26_M28_26_g N007_26 N007_26_M28_26_g 0.01
M28_26 S_26_M28_26_d N007_26_M28_26_g 0 0 nmos l=1u w=1u
C_S_26 S_26 0 1f
* --- Bit 27 ---
R_VDD_M1_27_d VDD VDD_M1_27_d 0.01
R_A_27_M1_27_g A_27 A_27_M1_27_g 0.01
R_N003_27_M1_27_s N003_27 N003_27_M1_27_s 0.01
R_VDD_M1_27_b VDD VDD_M1_27_b 0.01
M1_27 VDD_M1_27_d A_27_M1_27_g N003_27_M1_27_s VDD_M1_27_b pmos l=1u w=4u
R_N003_27_M2_27_d N003_27 N003_27_M2_27_d 0.01
R_B_27_M2_27_g B_27 B_27_M2_27_g 0.01
R_N005_27_M2_27_s N005_27 N005_27_M2_27_s 0.01
R_VDD_M2_27_b VDD VDD_M2_27_b 0.01
M2_27 N003_27_M2_27_d B_27_M2_27_g N005_27_M2_27_s VDD_M2_27_b pmos l=1u w=4u
R_VDD_M3_27_d VDD VDD_M3_27_d 0.01
R_A_27_M3_27_g A_27 A_27_M3_27_g 0.01
R_N001_27_M3_27_s N001_27 N001_27_M3_27_s 0.01
R_VDD_M3_27_b VDD VDD_M3_27_b 0.01
M3_27 VDD_M3_27_d A_27_M3_27_g N001_27_M3_27_s VDD_M3_27_b pmos l=1u w=4u
R_N001_27_M4_27_d N001_27 N001_27_M4_27_d 0.01
R_C_27_M4_27_g C_27 C_27_M4_27_g 0.01
R_N005_27_M4_27_s N005_27 N005_27_M4_27_s 0.01
R_VDD_M4_27_b VDD VDD_M4_27_b 0.01
M4_27 N001_27_M4_27_d C_27_M4_27_g N005_27_M4_27_s VDD_M4_27_b pmos l=1u w=4u
R_VDD_M5_27_d VDD VDD_M5_27_d 0.01
R_B_27_M5_27_g B_27 B_27_M5_27_g 0.01
R_N001_27_M5_27_s N001_27 N001_27_M5_27_s 0.01
R_VDD_M5_27_b VDD VDD_M5_27_b 0.01
M5_27 VDD_M5_27_d B_27_M5_27_g N001_27_M5_27_s VDD_M5_27_b pmos l=1u w=4u
R_VDD_M6_27_d VDD VDD_M6_27_d 0.01
R_N005_27_M6_27_g N005_27 N005_27_M6_27_g 0.01
R_C_28_M6_27_s C_28 C_28_M6_27_s 0.01
R_VDD_M6_27_b VDD VDD_M6_27_b 0.01
M6_27 VDD_M6_27_d N005_27_M6_27_g C_28_M6_27_s VDD_M6_27_b pmos l=1u w=2u
R_VDD_M7_27_d VDD VDD_M7_27_d 0.01
R_A_27_M7_27_g A_27 A_27_M7_27_g 0.01
R_N002_27_M7_27_s N002_27 N002_27_M7_27_s 0.01
R_VDD_M7_27_b VDD VDD_M7_27_b 0.01
M7_27 VDD_M7_27_d A_27_M7_27_g N002_27_M7_27_s VDD_M7_27_b pmos l=1u w=4u
R_VDD_M8_27_d VDD VDD_M8_27_d 0.01
R_B_27_M8_27_g B_27 B_27_M8_27_g 0.01
R_N002_27_M8_27_s N002_27 N002_27_M8_27_s 0.01
R_VDD_M8_27_b VDD VDD_M8_27_b 0.01
M8_27 VDD_M8_27_d B_27_M8_27_g N002_27_M8_27_s VDD_M8_27_b pmos l=1u w=4u
R_VDD_M9_27_d VDD VDD_M9_27_d 0.01
R_C_27_M9_27_g C_27 C_27_M9_27_g 0.01
R_N002_27_M9_27_s N002_27 N002_27_M9_27_s 0.01
R_VDD_M9_27_b VDD VDD_M9_27_b 0.01
M9_27 VDD_M9_27_d C_27_M9_27_g N002_27_M9_27_s VDD_M9_27_b pmos l=1u w=4u
R_VDD_M10_27_d VDD VDD_M10_27_d 0.01
R_A_27_M10_27_g A_27 A_27_M10_27_g 0.01
R_N004_27_M10_27_s N004_27 N004_27_M10_27_s 0.01
R_VDD_M10_27_b VDD VDD_M10_27_b 0.01
M10_27 VDD_M10_27_d A_27_M10_27_g N004_27_M10_27_s VDD_M10_27_b pmos l=1u w=8u
R_N004_27_M11_27_d N004_27 N004_27_M11_27_d 0.01
R_B_27_M11_27_g B_27 B_27_M11_27_g 0.01
R_N006_27_M11_27_s N006_27 N006_27_M11_27_s 0.01
R_VDD_M11_27_b VDD VDD_M11_27_b 0.01
M11_27 N004_27_M11_27_d B_27_M11_27_g N006_27_M11_27_s VDD_M11_27_b pmos l=1u w=8u
R_N006_27_M12_27_d N006_27 N006_27_M12_27_d 0.01
R_C_27_M12_27_g C_27 C_27_M12_27_g 0.01
R_N007_27_M12_27_s N007_27 N007_27_M12_27_s 0.01
R_VDD_M12_27_b VDD VDD_M12_27_b 0.01
M12_27 N006_27_M12_27_d C_27_M12_27_g N007_27_M12_27_s VDD_M12_27_b pmos l=1u w=8u
R_N007_27_M13_27_d N007_27 N007_27_M13_27_d 0.01
R_C_27_M13_27_g C_27 C_27_M13_27_g 0.01
R_N008_27_M13_27_s N008_27 N008_27_M13_27_s 0.01
M13_27 N007_27_M13_27_d C_27_M13_27_g N008_27_M13_27_s 0 nmos l=1u w=8u
R_N008_27_M14_27_d N008_27 N008_27_M14_27_d 0.01
R_B_27_M14_27_g B_27 B_27_M14_27_g 0.01
R_N012_27_M14_27_s N012_27 N012_27_M14_27_s 0.01
M14_27 N008_27_M14_27_d B_27_M14_27_g N012_27_M14_27_s 0 nmos l=1u w=8u
R_N012_27_M15_27_d N012_27 N012_27_M15_27_d 0.01
R_A_27_M15_27_g A_27 A_27_M15_27_g 0.01
M15_27 N012_27_M15_27_d A_27_M15_27_g 0 0 nmos l=1u w=8u
R_N010_27_M16_27_d N010_27 N010_27_M16_27_d 0.01
R_C_27_M16_27_g C_27 C_27_M16_27_g 0.01
M16_27 N010_27_M16_27_d C_27_M16_27_g 0 0 nmos l=1u w=2u
R_N010_27_M17_27_d N010_27 N010_27_M17_27_d 0.01
R_B_27_M17_27_g B_27 B_27_M17_27_g 0.01
M17_27 N010_27_M17_27_d B_27_M17_27_g 0 0 nmos l=1u w=2u
R_N010_27_M18_27_d N010_27 N010_27_M18_27_d 0.01
R_A_27_M18_27_g A_27 A_27_M18_27_g 0.01
M18_27 N010_27_M18_27_d A_27_M18_27_g 0 0 nmos l=1u w=2u
R_N007_27_M19_27_d N007_27 N007_27_M19_27_d 0.01
R_N005_27_M19_27_g N005_27 N005_27_M19_27_g 0.01
R_N010_27_M19_27_s N010_27 N010_27_M19_27_s 0.01
M19_27 N007_27_M19_27_d N005_27_M19_27_g N010_27_M19_27_s 0 nmos l=1u w=2u
R_N009_27_M20_27_d N009_27 N009_27_M20_27_d 0.01
R_B_27_M20_27_g B_27 B_27_M20_27_g 0.01
M20_27 N009_27_M20_27_d B_27_M20_27_g 0 0 nmos l=1u w=2u
R_N009_27_M21_27_d N009_27 N009_27_M21_27_d 0.01
R_A_27_M21_27_g A_27 A_27_M21_27_g 0.01
M21_27 N009_27_M21_27_d A_27_M21_27_g 0 0 nmos l=1u w=2u
R_N011_27_M22_27_d N011_27 N011_27_M22_27_d 0.01
R_A_27_M22_27_g A_27 A_27_M22_27_g 0.01
M22_27 N011_27_M22_27_d A_27_M22_27_g 0 0 nmos l=1u w=2u
R_N005_27_M23_27_d N005_27 N005_27_M23_27_d 0.01
R_B_27_M23_27_g B_27 B_27_M23_27_g 0.01
R_N011_27_M23_27_s N011_27 N011_27_M23_27_s 0.01
M23_27 N005_27_M23_27_d B_27_M23_27_g N011_27_M23_27_s 0 nmos l=1u w=2u
R_N005_27_M24_27_d N005_27 N005_27_M24_27_d 0.01
R_C_27_M24_27_g C_27 C_27_M24_27_g 0.01
R_N009_27_M24_27_s N009_27 N009_27_M24_27_s 0.01
M24_27 N005_27_M24_27_d C_27_M24_27_g N009_27_M24_27_s 0 nmos l=1u w=2u
R_C_28_M25_27_d C_28 C_28_M25_27_d 0.01
R_N005_27_M25_27_g N005_27 N005_27_M25_27_g 0.01
M25_27 C_28_M25_27_d N005_27_M25_27_g 0 0 nmos l=1u w=1u
R_N002_27_M26_27_d N002_27 N002_27_M26_27_d 0.01
R_N005_27_M26_27_g N005_27 N005_27_M26_27_g 0.01
R_N007_27_M26_27_s N007_27 N007_27_M26_27_s 0.01
R_VDD_M26_27_b VDD VDD_M26_27_b 0.01
M26_27 N002_27_M26_27_d N005_27_M26_27_g N007_27_M26_27_s VDD_M26_27_b pmos l=1u w=4u
R_VDD_M27_27_d VDD VDD_M27_27_d 0.01
R_N007_27_M27_27_g N007_27 N007_27_M27_27_g 0.01
R_S_27_M27_27_s S_27 S_27_M27_27_s 0.01
R_VDD_M27_27_b VDD VDD_M27_27_b 0.01
M27_27 VDD_M27_27_d N007_27_M27_27_g S_27_M27_27_s VDD_M27_27_b pmos l=1u w=2u
R_S_27_M28_27_d S_27 S_27_M28_27_d 0.01
R_N007_27_M28_27_g N007_27 N007_27_M28_27_g 0.01
M28_27 S_27_M28_27_d N007_27_M28_27_g 0 0 nmos l=1u w=1u
C_S_27 S_27 0 1f
* --- Bit 28 ---
R_VDD_M1_28_d VDD VDD_M1_28_d 0.01
R_A_28_M1_28_g A_28 A_28_M1_28_g 0.01
R_N003_28_M1_28_s N003_28 N003_28_M1_28_s 0.01
R_VDD_M1_28_b VDD VDD_M1_28_b 0.01
M1_28 VDD_M1_28_d A_28_M1_28_g N003_28_M1_28_s VDD_M1_28_b pmos l=1u w=4u
R_N003_28_M2_28_d N003_28 N003_28_M2_28_d 0.01
R_B_28_M2_28_g B_28 B_28_M2_28_g 0.01
R_N005_28_M2_28_s N005_28 N005_28_M2_28_s 0.01
R_VDD_M2_28_b VDD VDD_M2_28_b 0.01
M2_28 N003_28_M2_28_d B_28_M2_28_g N005_28_M2_28_s VDD_M2_28_b pmos l=1u w=4u
R_VDD_M3_28_d VDD VDD_M3_28_d 0.01
R_A_28_M3_28_g A_28 A_28_M3_28_g 0.01
R_N001_28_M3_28_s N001_28 N001_28_M3_28_s 0.01
R_VDD_M3_28_b VDD VDD_M3_28_b 0.01
M3_28 VDD_M3_28_d A_28_M3_28_g N001_28_M3_28_s VDD_M3_28_b pmos l=1u w=4u
R_N001_28_M4_28_d N001_28 N001_28_M4_28_d 0.01
R_C_28_M4_28_g C_28 C_28_M4_28_g 0.01
R_N005_28_M4_28_s N005_28 N005_28_M4_28_s 0.01
R_VDD_M4_28_b VDD VDD_M4_28_b 0.01
M4_28 N001_28_M4_28_d C_28_M4_28_g N005_28_M4_28_s VDD_M4_28_b pmos l=1u w=4u
R_VDD_M5_28_d VDD VDD_M5_28_d 0.01
R_B_28_M5_28_g B_28 B_28_M5_28_g 0.01
R_N001_28_M5_28_s N001_28 N001_28_M5_28_s 0.01
R_VDD_M5_28_b VDD VDD_M5_28_b 0.01
M5_28 VDD_M5_28_d B_28_M5_28_g N001_28_M5_28_s VDD_M5_28_b pmos l=1u w=4u
R_VDD_M6_28_d VDD VDD_M6_28_d 0.01
R_N005_28_M6_28_g N005_28 N005_28_M6_28_g 0.01
R_C_29_M6_28_s C_29 C_29_M6_28_s 0.01
R_VDD_M6_28_b VDD VDD_M6_28_b 0.01
M6_28 VDD_M6_28_d N005_28_M6_28_g C_29_M6_28_s VDD_M6_28_b pmos l=1u w=2u
R_VDD_M7_28_d VDD VDD_M7_28_d 0.01
R_A_28_M7_28_g A_28 A_28_M7_28_g 0.01
R_N002_28_M7_28_s N002_28 N002_28_M7_28_s 0.01
R_VDD_M7_28_b VDD VDD_M7_28_b 0.01
M7_28 VDD_M7_28_d A_28_M7_28_g N002_28_M7_28_s VDD_M7_28_b pmos l=1u w=4u
R_VDD_M8_28_d VDD VDD_M8_28_d 0.01
R_B_28_M8_28_g B_28 B_28_M8_28_g 0.01
R_N002_28_M8_28_s N002_28 N002_28_M8_28_s 0.01
R_VDD_M8_28_b VDD VDD_M8_28_b 0.01
M8_28 VDD_M8_28_d B_28_M8_28_g N002_28_M8_28_s VDD_M8_28_b pmos l=1u w=4u
R_VDD_M9_28_d VDD VDD_M9_28_d 0.01
R_C_28_M9_28_g C_28 C_28_M9_28_g 0.01
R_N002_28_M9_28_s N002_28 N002_28_M9_28_s 0.01
R_VDD_M9_28_b VDD VDD_M9_28_b 0.01
M9_28 VDD_M9_28_d C_28_M9_28_g N002_28_M9_28_s VDD_M9_28_b pmos l=1u w=4u
R_VDD_M10_28_d VDD VDD_M10_28_d 0.01
R_A_28_M10_28_g A_28 A_28_M10_28_g 0.01
R_N004_28_M10_28_s N004_28 N004_28_M10_28_s 0.01
R_VDD_M10_28_b VDD VDD_M10_28_b 0.01
M10_28 VDD_M10_28_d A_28_M10_28_g N004_28_M10_28_s VDD_M10_28_b pmos l=1u w=8u
R_N004_28_M11_28_d N004_28 N004_28_M11_28_d 0.01
R_B_28_M11_28_g B_28 B_28_M11_28_g 0.01
R_N006_28_M11_28_s N006_28 N006_28_M11_28_s 0.01
R_VDD_M11_28_b VDD VDD_M11_28_b 0.01
M11_28 N004_28_M11_28_d B_28_M11_28_g N006_28_M11_28_s VDD_M11_28_b pmos l=1u w=8u
R_N006_28_M12_28_d N006_28 N006_28_M12_28_d 0.01
R_C_28_M12_28_g C_28 C_28_M12_28_g 0.01
R_N007_28_M12_28_s N007_28 N007_28_M12_28_s 0.01
R_VDD_M12_28_b VDD VDD_M12_28_b 0.01
M12_28 N006_28_M12_28_d C_28_M12_28_g N007_28_M12_28_s VDD_M12_28_b pmos l=1u w=8u
R_N007_28_M13_28_d N007_28 N007_28_M13_28_d 0.01
R_C_28_M13_28_g C_28 C_28_M13_28_g 0.01
R_N008_28_M13_28_s N008_28 N008_28_M13_28_s 0.01
M13_28 N007_28_M13_28_d C_28_M13_28_g N008_28_M13_28_s 0 nmos l=1u w=8u
R_N008_28_M14_28_d N008_28 N008_28_M14_28_d 0.01
R_B_28_M14_28_g B_28 B_28_M14_28_g 0.01
R_N012_28_M14_28_s N012_28 N012_28_M14_28_s 0.01
M14_28 N008_28_M14_28_d B_28_M14_28_g N012_28_M14_28_s 0 nmos l=1u w=8u
R_N012_28_M15_28_d N012_28 N012_28_M15_28_d 0.01
R_A_28_M15_28_g A_28 A_28_M15_28_g 0.01
M15_28 N012_28_M15_28_d A_28_M15_28_g 0 0 nmos l=1u w=8u
R_N010_28_M16_28_d N010_28 N010_28_M16_28_d 0.01
R_C_28_M16_28_g C_28 C_28_M16_28_g 0.01
M16_28 N010_28_M16_28_d C_28_M16_28_g 0 0 nmos l=1u w=2u
R_N010_28_M17_28_d N010_28 N010_28_M17_28_d 0.01
R_B_28_M17_28_g B_28 B_28_M17_28_g 0.01
M17_28 N010_28_M17_28_d B_28_M17_28_g 0 0 nmos l=1u w=2u
R_N010_28_M18_28_d N010_28 N010_28_M18_28_d 0.01
R_A_28_M18_28_g A_28 A_28_M18_28_g 0.01
M18_28 N010_28_M18_28_d A_28_M18_28_g 0 0 nmos l=1u w=2u
R_N007_28_M19_28_d N007_28 N007_28_M19_28_d 0.01
R_N005_28_M19_28_g N005_28 N005_28_M19_28_g 0.01
R_N010_28_M19_28_s N010_28 N010_28_M19_28_s 0.01
M19_28 N007_28_M19_28_d N005_28_M19_28_g N010_28_M19_28_s 0 nmos l=1u w=2u
R_N009_28_M20_28_d N009_28 N009_28_M20_28_d 0.01
R_B_28_M20_28_g B_28 B_28_M20_28_g 0.01
M20_28 N009_28_M20_28_d B_28_M20_28_g 0 0 nmos l=1u w=2u
R_N009_28_M21_28_d N009_28 N009_28_M21_28_d 0.01
R_A_28_M21_28_g A_28 A_28_M21_28_g 0.01
M21_28 N009_28_M21_28_d A_28_M21_28_g 0 0 nmos l=1u w=2u
R_N011_28_M22_28_d N011_28 N011_28_M22_28_d 0.01
R_A_28_M22_28_g A_28 A_28_M22_28_g 0.01
M22_28 N011_28_M22_28_d A_28_M22_28_g 0 0 nmos l=1u w=2u
R_N005_28_M23_28_d N005_28 N005_28_M23_28_d 0.01
R_B_28_M23_28_g B_28 B_28_M23_28_g 0.01
R_N011_28_M23_28_s N011_28 N011_28_M23_28_s 0.01
M23_28 N005_28_M23_28_d B_28_M23_28_g N011_28_M23_28_s 0 nmos l=1u w=2u
R_N005_28_M24_28_d N005_28 N005_28_M24_28_d 0.01
R_C_28_M24_28_g C_28 C_28_M24_28_g 0.01
R_N009_28_M24_28_s N009_28 N009_28_M24_28_s 0.01
M24_28 N005_28_M24_28_d C_28_M24_28_g N009_28_M24_28_s 0 nmos l=1u w=2u
R_C_29_M25_28_d C_29 C_29_M25_28_d 0.01
R_N005_28_M25_28_g N005_28 N005_28_M25_28_g 0.01
M25_28 C_29_M25_28_d N005_28_M25_28_g 0 0 nmos l=1u w=1u
R_N002_28_M26_28_d N002_28 N002_28_M26_28_d 0.01
R_N005_28_M26_28_g N005_28 N005_28_M26_28_g 0.01
R_N007_28_M26_28_s N007_28 N007_28_M26_28_s 0.01
R_VDD_M26_28_b VDD VDD_M26_28_b 0.01
M26_28 N002_28_M26_28_d N005_28_M26_28_g N007_28_M26_28_s VDD_M26_28_b pmos l=1u w=4u
R_VDD_M27_28_d VDD VDD_M27_28_d 0.01
R_N007_28_M27_28_g N007_28 N007_28_M27_28_g 0.01
R_S_28_M27_28_s S_28 S_28_M27_28_s 0.01
R_VDD_M27_28_b VDD VDD_M27_28_b 0.01
M27_28 VDD_M27_28_d N007_28_M27_28_g S_28_M27_28_s VDD_M27_28_b pmos l=1u w=2u
R_S_28_M28_28_d S_28 S_28_M28_28_d 0.01
R_N007_28_M28_28_g N007_28 N007_28_M28_28_g 0.01
M28_28 S_28_M28_28_d N007_28_M28_28_g 0 0 nmos l=1u w=1u
C_S_28 S_28 0 1f
* --- Bit 29 ---
R_VDD_M1_29_d VDD VDD_M1_29_d 0.01
R_A_29_M1_29_g A_29 A_29_M1_29_g 0.01
R_N003_29_M1_29_s N003_29 N003_29_M1_29_s 0.01
R_VDD_M1_29_b VDD VDD_M1_29_b 0.01
M1_29 VDD_M1_29_d A_29_M1_29_g N003_29_M1_29_s VDD_M1_29_b pmos l=1u w=4u
R_N003_29_M2_29_d N003_29 N003_29_M2_29_d 0.01
R_B_29_M2_29_g B_29 B_29_M2_29_g 0.01
R_N005_29_M2_29_s N005_29 N005_29_M2_29_s 0.01
R_VDD_M2_29_b VDD VDD_M2_29_b 0.01
M2_29 N003_29_M2_29_d B_29_M2_29_g N005_29_M2_29_s VDD_M2_29_b pmos l=1u w=4u
R_VDD_M3_29_d VDD VDD_M3_29_d 0.01
R_A_29_M3_29_g A_29 A_29_M3_29_g 0.01
R_N001_29_M3_29_s N001_29 N001_29_M3_29_s 0.01
R_VDD_M3_29_b VDD VDD_M3_29_b 0.01
M3_29 VDD_M3_29_d A_29_M3_29_g N001_29_M3_29_s VDD_M3_29_b pmos l=1u w=4u
R_N001_29_M4_29_d N001_29 N001_29_M4_29_d 0.01
R_C_29_M4_29_g C_29 C_29_M4_29_g 0.01
R_N005_29_M4_29_s N005_29 N005_29_M4_29_s 0.01
R_VDD_M4_29_b VDD VDD_M4_29_b 0.01
M4_29 N001_29_M4_29_d C_29_M4_29_g N005_29_M4_29_s VDD_M4_29_b pmos l=1u w=4u
R_VDD_M5_29_d VDD VDD_M5_29_d 0.01
R_B_29_M5_29_g B_29 B_29_M5_29_g 0.01
R_N001_29_M5_29_s N001_29 N001_29_M5_29_s 0.01
R_VDD_M5_29_b VDD VDD_M5_29_b 0.01
M5_29 VDD_M5_29_d B_29_M5_29_g N001_29_M5_29_s VDD_M5_29_b pmos l=1u w=4u
R_VDD_M6_29_d VDD VDD_M6_29_d 0.01
R_N005_29_M6_29_g N005_29 N005_29_M6_29_g 0.01
R_C_30_M6_29_s C_30 C_30_M6_29_s 0.01
R_VDD_M6_29_b VDD VDD_M6_29_b 0.01
M6_29 VDD_M6_29_d N005_29_M6_29_g C_30_M6_29_s VDD_M6_29_b pmos l=1u w=2u
R_VDD_M7_29_d VDD VDD_M7_29_d 0.01
R_A_29_M7_29_g A_29 A_29_M7_29_g 0.01
R_N002_29_M7_29_s N002_29 N002_29_M7_29_s 0.01
R_VDD_M7_29_b VDD VDD_M7_29_b 0.01
M7_29 VDD_M7_29_d A_29_M7_29_g N002_29_M7_29_s VDD_M7_29_b pmos l=1u w=4u
R_VDD_M8_29_d VDD VDD_M8_29_d 0.01
R_B_29_M8_29_g B_29 B_29_M8_29_g 0.01
R_N002_29_M8_29_s N002_29 N002_29_M8_29_s 0.01
R_VDD_M8_29_b VDD VDD_M8_29_b 0.01
M8_29 VDD_M8_29_d B_29_M8_29_g N002_29_M8_29_s VDD_M8_29_b pmos l=1u w=4u
R_VDD_M9_29_d VDD VDD_M9_29_d 0.01
R_C_29_M9_29_g C_29 C_29_M9_29_g 0.01
R_N002_29_M9_29_s N002_29 N002_29_M9_29_s 0.01
R_VDD_M9_29_b VDD VDD_M9_29_b 0.01
M9_29 VDD_M9_29_d C_29_M9_29_g N002_29_M9_29_s VDD_M9_29_b pmos l=1u w=4u
R_VDD_M10_29_d VDD VDD_M10_29_d 0.01
R_A_29_M10_29_g A_29 A_29_M10_29_g 0.01
R_N004_29_M10_29_s N004_29 N004_29_M10_29_s 0.01
R_VDD_M10_29_b VDD VDD_M10_29_b 0.01
M10_29 VDD_M10_29_d A_29_M10_29_g N004_29_M10_29_s VDD_M10_29_b pmos l=1u w=8u
R_N004_29_M11_29_d N004_29 N004_29_M11_29_d 0.01
R_B_29_M11_29_g B_29 B_29_M11_29_g 0.01
R_N006_29_M11_29_s N006_29 N006_29_M11_29_s 0.01
R_VDD_M11_29_b VDD VDD_M11_29_b 0.01
M11_29 N004_29_M11_29_d B_29_M11_29_g N006_29_M11_29_s VDD_M11_29_b pmos l=1u w=8u
R_N006_29_M12_29_d N006_29 N006_29_M12_29_d 0.01
R_C_29_M12_29_g C_29 C_29_M12_29_g 0.01
R_N007_29_M12_29_s N007_29 N007_29_M12_29_s 0.01
R_VDD_M12_29_b VDD VDD_M12_29_b 0.01
M12_29 N006_29_M12_29_d C_29_M12_29_g N007_29_M12_29_s VDD_M12_29_b pmos l=1u w=8u
R_N007_29_M13_29_d N007_29 N007_29_M13_29_d 0.01
R_C_29_M13_29_g C_29 C_29_M13_29_g 0.01
R_N008_29_M13_29_s N008_29 N008_29_M13_29_s 0.01
M13_29 N007_29_M13_29_d C_29_M13_29_g N008_29_M13_29_s 0 nmos l=1u w=8u
R_N008_29_M14_29_d N008_29 N008_29_M14_29_d 0.01
R_B_29_M14_29_g B_29 B_29_M14_29_g 0.01
R_N012_29_M14_29_s N012_29 N012_29_M14_29_s 0.01
M14_29 N008_29_M14_29_d B_29_M14_29_g N012_29_M14_29_s 0 nmos l=1u w=8u
R_N012_29_M15_29_d N012_29 N012_29_M15_29_d 0.01
R_A_29_M15_29_g A_29 A_29_M15_29_g 0.01
M15_29 N012_29_M15_29_d A_29_M15_29_g 0 0 nmos l=1u w=8u
R_N010_29_M16_29_d N010_29 N010_29_M16_29_d 0.01
R_C_29_M16_29_g C_29 C_29_M16_29_g 0.01
M16_29 N010_29_M16_29_d C_29_M16_29_g 0 0 nmos l=1u w=2u
R_N010_29_M17_29_d N010_29 N010_29_M17_29_d 0.01
R_B_29_M17_29_g B_29 B_29_M17_29_g 0.01
M17_29 N010_29_M17_29_d B_29_M17_29_g 0 0 nmos l=1u w=2u
R_N010_29_M18_29_d N010_29 N010_29_M18_29_d 0.01
R_A_29_M18_29_g A_29 A_29_M18_29_g 0.01
M18_29 N010_29_M18_29_d A_29_M18_29_g 0 0 nmos l=1u w=2u
R_N007_29_M19_29_d N007_29 N007_29_M19_29_d 0.01
R_N005_29_M19_29_g N005_29 N005_29_M19_29_g 0.01
R_N010_29_M19_29_s N010_29 N010_29_M19_29_s 0.01
M19_29 N007_29_M19_29_d N005_29_M19_29_g N010_29_M19_29_s 0 nmos l=1u w=2u
R_N009_29_M20_29_d N009_29 N009_29_M20_29_d 0.01
R_B_29_M20_29_g B_29 B_29_M20_29_g 0.01
M20_29 N009_29_M20_29_d B_29_M20_29_g 0 0 nmos l=1u w=2u
R_N009_29_M21_29_d N009_29 N009_29_M21_29_d 0.01
R_A_29_M21_29_g A_29 A_29_M21_29_g 0.01
M21_29 N009_29_M21_29_d A_29_M21_29_g 0 0 nmos l=1u w=2u
R_N011_29_M22_29_d N011_29 N011_29_M22_29_d 0.01
R_A_29_M22_29_g A_29 A_29_M22_29_g 0.01
M22_29 N011_29_M22_29_d A_29_M22_29_g 0 0 nmos l=1u w=2u
R_N005_29_M23_29_d N005_29 N005_29_M23_29_d 0.01
R_B_29_M23_29_g B_29 B_29_M23_29_g 0.01
R_N011_29_M23_29_s N011_29 N011_29_M23_29_s 0.01
M23_29 N005_29_M23_29_d B_29_M23_29_g N011_29_M23_29_s 0 nmos l=1u w=2u
R_N005_29_M24_29_d N005_29 N005_29_M24_29_d 0.01
R_C_29_M24_29_g C_29 C_29_M24_29_g 0.01
R_N009_29_M24_29_s N009_29 N009_29_M24_29_s 0.01
M24_29 N005_29_M24_29_d C_29_M24_29_g N009_29_M24_29_s 0 nmos l=1u w=2u
R_C_30_M25_29_d C_30 C_30_M25_29_d 0.01
R_N005_29_M25_29_g N005_29 N005_29_M25_29_g 0.01
M25_29 C_30_M25_29_d N005_29_M25_29_g 0 0 nmos l=1u w=1u
R_N002_29_M26_29_d N002_29 N002_29_M26_29_d 0.01
R_N005_29_M26_29_g N005_29 N005_29_M26_29_g 0.01
R_N007_29_M26_29_s N007_29 N007_29_M26_29_s 0.01
R_VDD_M26_29_b VDD VDD_M26_29_b 0.01
M26_29 N002_29_M26_29_d N005_29_M26_29_g N007_29_M26_29_s VDD_M26_29_b pmos l=1u w=4u
R_VDD_M27_29_d VDD VDD_M27_29_d 0.01
R_N007_29_M27_29_g N007_29 N007_29_M27_29_g 0.01
R_S_29_M27_29_s S_29 S_29_M27_29_s 0.01
R_VDD_M27_29_b VDD VDD_M27_29_b 0.01
M27_29 VDD_M27_29_d N007_29_M27_29_g S_29_M27_29_s VDD_M27_29_b pmos l=1u w=2u
R_S_29_M28_29_d S_29 S_29_M28_29_d 0.01
R_N007_29_M28_29_g N007_29 N007_29_M28_29_g 0.01
M28_29 S_29_M28_29_d N007_29_M28_29_g 0 0 nmos l=1u w=1u
C_S_29 S_29 0 1f
* --- Bit 30 ---
R_VDD_M1_30_d VDD VDD_M1_30_d 0.01
R_A_30_M1_30_g A_30 A_30_M1_30_g 0.01
R_N003_30_M1_30_s N003_30 N003_30_M1_30_s 0.01
R_VDD_M1_30_b VDD VDD_M1_30_b 0.01
M1_30 VDD_M1_30_d A_30_M1_30_g N003_30_M1_30_s VDD_M1_30_b pmos l=1u w=4u
R_N003_30_M2_30_d N003_30 N003_30_M2_30_d 0.01
R_B_30_M2_30_g B_30 B_30_M2_30_g 0.01
R_N005_30_M2_30_s N005_30 N005_30_M2_30_s 0.01
R_VDD_M2_30_b VDD VDD_M2_30_b 0.01
M2_30 N003_30_M2_30_d B_30_M2_30_g N005_30_M2_30_s VDD_M2_30_b pmos l=1u w=4u
R_VDD_M3_30_d VDD VDD_M3_30_d 0.01
R_A_30_M3_30_g A_30 A_30_M3_30_g 0.01
R_N001_30_M3_30_s N001_30 N001_30_M3_30_s 0.01
R_VDD_M3_30_b VDD VDD_M3_30_b 0.01
M3_30 VDD_M3_30_d A_30_M3_30_g N001_30_M3_30_s VDD_M3_30_b pmos l=1u w=4u
R_N001_30_M4_30_d N001_30 N001_30_M4_30_d 0.01
R_C_30_M4_30_g C_30 C_30_M4_30_g 0.01
R_N005_30_M4_30_s N005_30 N005_30_M4_30_s 0.01
R_VDD_M4_30_b VDD VDD_M4_30_b 0.01
M4_30 N001_30_M4_30_d C_30_M4_30_g N005_30_M4_30_s VDD_M4_30_b pmos l=1u w=4u
R_VDD_M5_30_d VDD VDD_M5_30_d 0.01
R_B_30_M5_30_g B_30 B_30_M5_30_g 0.01
R_N001_30_M5_30_s N001_30 N001_30_M5_30_s 0.01
R_VDD_M5_30_b VDD VDD_M5_30_b 0.01
M5_30 VDD_M5_30_d B_30_M5_30_g N001_30_M5_30_s VDD_M5_30_b pmos l=1u w=4u
R_VDD_M6_30_d VDD VDD_M6_30_d 0.01
R_N005_30_M6_30_g N005_30 N005_30_M6_30_g 0.01
R_C_31_M6_30_s C_31 C_31_M6_30_s 0.01
R_VDD_M6_30_b VDD VDD_M6_30_b 0.01
M6_30 VDD_M6_30_d N005_30_M6_30_g C_31_M6_30_s VDD_M6_30_b pmos l=1u w=2u
R_VDD_M7_30_d VDD VDD_M7_30_d 0.01
R_A_30_M7_30_g A_30 A_30_M7_30_g 0.01
R_N002_30_M7_30_s N002_30 N002_30_M7_30_s 0.01
R_VDD_M7_30_b VDD VDD_M7_30_b 0.01
M7_30 VDD_M7_30_d A_30_M7_30_g N002_30_M7_30_s VDD_M7_30_b pmos l=1u w=4u
R_VDD_M8_30_d VDD VDD_M8_30_d 0.01
R_B_30_M8_30_g B_30 B_30_M8_30_g 0.01
R_N002_30_M8_30_s N002_30 N002_30_M8_30_s 0.01
R_VDD_M8_30_b VDD VDD_M8_30_b 0.01
M8_30 VDD_M8_30_d B_30_M8_30_g N002_30_M8_30_s VDD_M8_30_b pmos l=1u w=4u
R_VDD_M9_30_d VDD VDD_M9_30_d 0.01
R_C_30_M9_30_g C_30 C_30_M9_30_g 0.01
R_N002_30_M9_30_s N002_30 N002_30_M9_30_s 0.01
R_VDD_M9_30_b VDD VDD_M9_30_b 0.01
M9_30 VDD_M9_30_d C_30_M9_30_g N002_30_M9_30_s VDD_M9_30_b pmos l=1u w=4u
R_VDD_M10_30_d VDD VDD_M10_30_d 0.01
R_A_30_M10_30_g A_30 A_30_M10_30_g 0.01
R_N004_30_M10_30_s N004_30 N004_30_M10_30_s 0.01
R_VDD_M10_30_b VDD VDD_M10_30_b 0.01
M10_30 VDD_M10_30_d A_30_M10_30_g N004_30_M10_30_s VDD_M10_30_b pmos l=1u w=8u
R_N004_30_M11_30_d N004_30 N004_30_M11_30_d 0.01
R_B_30_M11_30_g B_30 B_30_M11_30_g 0.01
R_N006_30_M11_30_s N006_30 N006_30_M11_30_s 0.01
R_VDD_M11_30_b VDD VDD_M11_30_b 0.01
M11_30 N004_30_M11_30_d B_30_M11_30_g N006_30_M11_30_s VDD_M11_30_b pmos l=1u w=8u
R_N006_30_M12_30_d N006_30 N006_30_M12_30_d 0.01
R_C_30_M12_30_g C_30 C_30_M12_30_g 0.01
R_N007_30_M12_30_s N007_30 N007_30_M12_30_s 0.01
R_VDD_M12_30_b VDD VDD_M12_30_b 0.01
M12_30 N006_30_M12_30_d C_30_M12_30_g N007_30_M12_30_s VDD_M12_30_b pmos l=1u w=8u
R_N007_30_M13_30_d N007_30 N007_30_M13_30_d 0.01
R_C_30_M13_30_g C_30 C_30_M13_30_g 0.01
R_N008_30_M13_30_s N008_30 N008_30_M13_30_s 0.01
M13_30 N007_30_M13_30_d C_30_M13_30_g N008_30_M13_30_s 0 nmos l=1u w=8u
R_N008_30_M14_30_d N008_30 N008_30_M14_30_d 0.01
R_B_30_M14_30_g B_30 B_30_M14_30_g 0.01
R_N012_30_M14_30_s N012_30 N012_30_M14_30_s 0.01
M14_30 N008_30_M14_30_d B_30_M14_30_g N012_30_M14_30_s 0 nmos l=1u w=8u
R_N012_30_M15_30_d N012_30 N012_30_M15_30_d 0.01
R_A_30_M15_30_g A_30 A_30_M15_30_g 0.01
M15_30 N012_30_M15_30_d A_30_M15_30_g 0 0 nmos l=1u w=8u
R_N010_30_M16_30_d N010_30 N010_30_M16_30_d 0.01
R_C_30_M16_30_g C_30 C_30_M16_30_g 0.01
M16_30 N010_30_M16_30_d C_30_M16_30_g 0 0 nmos l=1u w=2u
R_N010_30_M17_30_d N010_30 N010_30_M17_30_d 0.01
R_B_30_M17_30_g B_30 B_30_M17_30_g 0.01
M17_30 N010_30_M17_30_d B_30_M17_30_g 0 0 nmos l=1u w=2u
R_N010_30_M18_30_d N010_30 N010_30_M18_30_d 0.01
R_A_30_M18_30_g A_30 A_30_M18_30_g 0.01
M18_30 N010_30_M18_30_d A_30_M18_30_g 0 0 nmos l=1u w=2u
R_N007_30_M19_30_d N007_30 N007_30_M19_30_d 0.01
R_N005_30_M19_30_g N005_30 N005_30_M19_30_g 0.01
R_N010_30_M19_30_s N010_30 N010_30_M19_30_s 0.01
M19_30 N007_30_M19_30_d N005_30_M19_30_g N010_30_M19_30_s 0 nmos l=1u w=2u
R_N009_30_M20_30_d N009_30 N009_30_M20_30_d 0.01
R_B_30_M20_30_g B_30 B_30_M20_30_g 0.01
M20_30 N009_30_M20_30_d B_30_M20_30_g 0 0 nmos l=1u w=2u
R_N009_30_M21_30_d N009_30 N009_30_M21_30_d 0.01
R_A_30_M21_30_g A_30 A_30_M21_30_g 0.01
M21_30 N009_30_M21_30_d A_30_M21_30_g 0 0 nmos l=1u w=2u
R_N011_30_M22_30_d N011_30 N011_30_M22_30_d 0.01
R_A_30_M22_30_g A_30 A_30_M22_30_g 0.01
M22_30 N011_30_M22_30_d A_30_M22_30_g 0 0 nmos l=1u w=2u
R_N005_30_M23_30_d N005_30 N005_30_M23_30_d 0.01
R_B_30_M23_30_g B_30 B_30_M23_30_g 0.01
R_N011_30_M23_30_s N011_30 N011_30_M23_30_s 0.01
M23_30 N005_30_M23_30_d B_30_M23_30_g N011_30_M23_30_s 0 nmos l=1u w=2u
R_N005_30_M24_30_d N005_30 N005_30_M24_30_d 0.01
R_C_30_M24_30_g C_30 C_30_M24_30_g 0.01
R_N009_30_M24_30_s N009_30 N009_30_M24_30_s 0.01
M24_30 N005_30_M24_30_d C_30_M24_30_g N009_30_M24_30_s 0 nmos l=1u w=2u
R_C_31_M25_30_d C_31 C_31_M25_30_d 0.01
R_N005_30_M25_30_g N005_30 N005_30_M25_30_g 0.01
M25_30 C_31_M25_30_d N005_30_M25_30_g 0 0 nmos l=1u w=1u
R_N002_30_M26_30_d N002_30 N002_30_M26_30_d 0.01
R_N005_30_M26_30_g N005_30 N005_30_M26_30_g 0.01
R_N007_30_M26_30_s N007_30 N007_30_M26_30_s 0.01
R_VDD_M26_30_b VDD VDD_M26_30_b 0.01
M26_30 N002_30_M26_30_d N005_30_M26_30_g N007_30_M26_30_s VDD_M26_30_b pmos l=1u w=4u
R_VDD_M27_30_d VDD VDD_M27_30_d 0.01
R_N007_30_M27_30_g N007_30 N007_30_M27_30_g 0.01
R_S_30_M27_30_s S_30 S_30_M27_30_s 0.01
R_VDD_M27_30_b VDD VDD_M27_30_b 0.01
M27_30 VDD_M27_30_d N007_30_M27_30_g S_30_M27_30_s VDD_M27_30_b pmos l=1u w=2u
R_S_30_M28_30_d S_30 S_30_M28_30_d 0.01
R_N007_30_M28_30_g N007_30 N007_30_M28_30_g 0.01
M28_30 S_30_M28_30_d N007_30_M28_30_g 0 0 nmos l=1u w=1u
C_S_30 S_30 0 1f
* --- Bit 31 ---
R_VDD_M1_31_d VDD VDD_M1_31_d 0.01
R_A_31_M1_31_g A_31 A_31_M1_31_g 0.01
R_N003_31_M1_31_s N003_31 N003_31_M1_31_s 0.01
R_VDD_M1_31_b VDD VDD_M1_31_b 0.01
M1_31 VDD_M1_31_d A_31_M1_31_g N003_31_M1_31_s VDD_M1_31_b pmos l=1u w=4u
R_N003_31_M2_31_d N003_31 N003_31_M2_31_d 0.01
R_B_31_M2_31_g B_31 B_31_M2_31_g 0.01
R_N005_31_M2_31_s N005_31 N005_31_M2_31_s 0.01
R_VDD_M2_31_b VDD VDD_M2_31_b 0.01
M2_31 N003_31_M2_31_d B_31_M2_31_g N005_31_M2_31_s VDD_M2_31_b pmos l=1u w=4u
R_VDD_M3_31_d VDD VDD_M3_31_d 0.01
R_A_31_M3_31_g A_31 A_31_M3_31_g 0.01
R_N001_31_M3_31_s N001_31 N001_31_M3_31_s 0.01
R_VDD_M3_31_b VDD VDD_M3_31_b 0.01
M3_31 VDD_M3_31_d A_31_M3_31_g N001_31_M3_31_s VDD_M3_31_b pmos l=1u w=4u
R_N001_31_M4_31_d N001_31 N001_31_M4_31_d 0.01
R_C_31_M4_31_g C_31 C_31_M4_31_g 0.01
R_N005_31_M4_31_s N005_31 N005_31_M4_31_s 0.01
R_VDD_M4_31_b VDD VDD_M4_31_b 0.01
M4_31 N001_31_M4_31_d C_31_M4_31_g N005_31_M4_31_s VDD_M4_31_b pmos l=1u w=4u
R_VDD_M5_31_d VDD VDD_M5_31_d 0.01
R_B_31_M5_31_g B_31 B_31_M5_31_g 0.01
R_N001_31_M5_31_s N001_31 N001_31_M5_31_s 0.01
R_VDD_M5_31_b VDD VDD_M5_31_b 0.01
M5_31 VDD_M5_31_d B_31_M5_31_g N001_31_M5_31_s VDD_M5_31_b pmos l=1u w=4u
R_VDD_M6_31_d VDD VDD_M6_31_d 0.01
R_N005_31_M6_31_g N005_31 N005_31_M6_31_g 0.01
R_C_32_M6_31_s C_32 C_32_M6_31_s 0.01
R_VDD_M6_31_b VDD VDD_M6_31_b 0.01
M6_31 VDD_M6_31_d N005_31_M6_31_g C_32_M6_31_s VDD_M6_31_b pmos l=1u w=2u
R_VDD_M7_31_d VDD VDD_M7_31_d 0.01
R_A_31_M7_31_g A_31 A_31_M7_31_g 0.01
R_N002_31_M7_31_s N002_31 N002_31_M7_31_s 0.01
R_VDD_M7_31_b VDD VDD_M7_31_b 0.01
M7_31 VDD_M7_31_d A_31_M7_31_g N002_31_M7_31_s VDD_M7_31_b pmos l=1u w=4u
R_VDD_M8_31_d VDD VDD_M8_31_d 0.01
R_B_31_M8_31_g B_31 B_31_M8_31_g 0.01
R_N002_31_M8_31_s N002_31 N002_31_M8_31_s 0.01
R_VDD_M8_31_b VDD VDD_M8_31_b 0.01
M8_31 VDD_M8_31_d B_31_M8_31_g N002_31_M8_31_s VDD_M8_31_b pmos l=1u w=4u
R_VDD_M9_31_d VDD VDD_M9_31_d 0.01
R_C_31_M9_31_g C_31 C_31_M9_31_g 0.01
R_N002_31_M9_31_s N002_31 N002_31_M9_31_s 0.01
R_VDD_M9_31_b VDD VDD_M9_31_b 0.01
M9_31 VDD_M9_31_d C_31_M9_31_g N002_31_M9_31_s VDD_M9_31_b pmos l=1u w=4u
R_VDD_M10_31_d VDD VDD_M10_31_d 0.01
R_A_31_M10_31_g A_31 A_31_M10_31_g 0.01
R_N004_31_M10_31_s N004_31 N004_31_M10_31_s 0.01
R_VDD_M10_31_b VDD VDD_M10_31_b 0.01
M10_31 VDD_M10_31_d A_31_M10_31_g N004_31_M10_31_s VDD_M10_31_b pmos l=1u w=8u
R_N004_31_M11_31_d N004_31 N004_31_M11_31_d 0.01
R_B_31_M11_31_g B_31 B_31_M11_31_g 0.01
R_N006_31_M11_31_s N006_31 N006_31_M11_31_s 0.01
R_VDD_M11_31_b VDD VDD_M11_31_b 0.01
M11_31 N004_31_M11_31_d B_31_M11_31_g N006_31_M11_31_s VDD_M11_31_b pmos l=1u w=8u
R_N006_31_M12_31_d N006_31 N006_31_M12_31_d 0.01
R_C_31_M12_31_g C_31 C_31_M12_31_g 0.01
R_N007_31_M12_31_s N007_31 N007_31_M12_31_s 0.01
R_VDD_M12_31_b VDD VDD_M12_31_b 0.01
M12_31 N006_31_M12_31_d C_31_M12_31_g N007_31_M12_31_s VDD_M12_31_b pmos l=1u w=8u
R_N007_31_M13_31_d N007_31 N007_31_M13_31_d 0.01
R_C_31_M13_31_g C_31 C_31_M13_31_g 0.01
R_N008_31_M13_31_s N008_31 N008_31_M13_31_s 0.01
M13_31 N007_31_M13_31_d C_31_M13_31_g N008_31_M13_31_s 0 nmos l=1u w=8u
R_N008_31_M14_31_d N008_31 N008_31_M14_31_d 0.01
R_B_31_M14_31_g B_31 B_31_M14_31_g 0.01
R_N012_31_M14_31_s N012_31 N012_31_M14_31_s 0.01
M14_31 N008_31_M14_31_d B_31_M14_31_g N012_31_M14_31_s 0 nmos l=1u w=8u
R_N012_31_M15_31_d N012_31 N012_31_M15_31_d 0.01
R_A_31_M15_31_g A_31 A_31_M15_31_g 0.01
M15_31 N012_31_M15_31_d A_31_M15_31_g 0 0 nmos l=1u w=8u
R_N010_31_M16_31_d N010_31 N010_31_M16_31_d 0.01
R_C_31_M16_31_g C_31 C_31_M16_31_g 0.01
M16_31 N010_31_M16_31_d C_31_M16_31_g 0 0 nmos l=1u w=2u
R_N010_31_M17_31_d N010_31 N010_31_M17_31_d 0.01
R_B_31_M17_31_g B_31 B_31_M17_31_g 0.01
M17_31 N010_31_M17_31_d B_31_M17_31_g 0 0 nmos l=1u w=2u
R_N010_31_M18_31_d N010_31 N010_31_M18_31_d 0.01
R_A_31_M18_31_g A_31 A_31_M18_31_g 0.01
M18_31 N010_31_M18_31_d A_31_M18_31_g 0 0 nmos l=1u w=2u
R_N007_31_M19_31_d N007_31 N007_31_M19_31_d 0.01
R_N005_31_M19_31_g N005_31 N005_31_M19_31_g 0.01
R_N010_31_M19_31_s N010_31 N010_31_M19_31_s 0.01
M19_31 N007_31_M19_31_d N005_31_M19_31_g N010_31_M19_31_s 0 nmos l=1u w=2u
R_N009_31_M20_31_d N009_31 N009_31_M20_31_d 0.01
R_B_31_M20_31_g B_31 B_31_M20_31_g 0.01
M20_31 N009_31_M20_31_d B_31_M20_31_g 0 0 nmos l=1u w=2u
R_N009_31_M21_31_d N009_31 N009_31_M21_31_d 0.01
R_A_31_M21_31_g A_31 A_31_M21_31_g 0.01
M21_31 N009_31_M21_31_d A_31_M21_31_g 0 0 nmos l=1u w=2u
R_N011_31_M22_31_d N011_31 N011_31_M22_31_d 0.01
R_A_31_M22_31_g A_31 A_31_M22_31_g 0.01
M22_31 N011_31_M22_31_d A_31_M22_31_g 0 0 nmos l=1u w=2u
R_N005_31_M23_31_d N005_31 N005_31_M23_31_d 0.01
R_B_31_M23_31_g B_31 B_31_M23_31_g 0.01
R_N011_31_M23_31_s N011_31 N011_31_M23_31_s 0.01
M23_31 N005_31_M23_31_d B_31_M23_31_g N011_31_M23_31_s 0 nmos l=1u w=2u
R_N005_31_M24_31_d N005_31 N005_31_M24_31_d 0.01
R_C_31_M24_31_g C_31 C_31_M24_31_g 0.01
R_N009_31_M24_31_s N009_31 N009_31_M24_31_s 0.01
M24_31 N005_31_M24_31_d C_31_M24_31_g N009_31_M24_31_s 0 nmos l=1u w=2u
R_C_32_M25_31_d C_32 C_32_M25_31_d 0.01
R_N005_31_M25_31_g N005_31 N005_31_M25_31_g 0.01
M25_31 C_32_M25_31_d N005_31_M25_31_g 0 0 nmos l=1u w=1u
R_N002_31_M26_31_d N002_31 N002_31_M26_31_d 0.01
R_N005_31_M26_31_g N005_31 N005_31_M26_31_g 0.01
R_N007_31_M26_31_s N007_31 N007_31_M26_31_s 0.01
R_VDD_M26_31_b VDD VDD_M26_31_b 0.01
M26_31 N002_31_M26_31_d N005_31_M26_31_g N007_31_M26_31_s VDD_M26_31_b pmos l=1u w=4u
R_VDD_M27_31_d VDD VDD_M27_31_d 0.01
R_N007_31_M27_31_g N007_31 N007_31_M27_31_g 0.01
R_S_31_M27_31_s S_31 S_31_M27_31_s 0.01
R_VDD_M27_31_b VDD VDD_M27_31_b 0.01
M27_31 VDD_M27_31_d N007_31_M27_31_g S_31_M27_31_s VDD_M27_31_b pmos l=1u w=2u
R_S_31_M28_31_d S_31 S_31_M28_31_d 0.01
R_N007_31_M28_31_g N007_31 N007_31_M28_31_g 0.01
M28_31 S_31_M28_31_d N007_31_M28_31_g 0 0 nmos l=1u w=1u
C_S_31 S_31 0 1f
* --- Bit 32 ---
R_VDD_M1_32_d VDD VDD_M1_32_d 0.01
R_A_32_M1_32_g A_32 A_32_M1_32_g 0.01
R_N003_32_M1_32_s N003_32 N003_32_M1_32_s 0.01
R_VDD_M1_32_b VDD VDD_M1_32_b 0.01
M1_32 VDD_M1_32_d A_32_M1_32_g N003_32_M1_32_s VDD_M1_32_b pmos l=1u w=4u
R_N003_32_M2_32_d N003_32 N003_32_M2_32_d 0.01
R_B_32_M2_32_g B_32 B_32_M2_32_g 0.01
R_N005_32_M2_32_s N005_32 N005_32_M2_32_s 0.01
R_VDD_M2_32_b VDD VDD_M2_32_b 0.01
M2_32 N003_32_M2_32_d B_32_M2_32_g N005_32_M2_32_s VDD_M2_32_b pmos l=1u w=4u
R_VDD_M3_32_d VDD VDD_M3_32_d 0.01
R_A_32_M3_32_g A_32 A_32_M3_32_g 0.01
R_N001_32_M3_32_s N001_32 N001_32_M3_32_s 0.01
R_VDD_M3_32_b VDD VDD_M3_32_b 0.01
M3_32 VDD_M3_32_d A_32_M3_32_g N001_32_M3_32_s VDD_M3_32_b pmos l=1u w=4u
R_N001_32_M4_32_d N001_32 N001_32_M4_32_d 0.01
R_C_32_M4_32_g C_32 C_32_M4_32_g 0.01
R_N005_32_M4_32_s N005_32 N005_32_M4_32_s 0.01
R_VDD_M4_32_b VDD VDD_M4_32_b 0.01
M4_32 N001_32_M4_32_d C_32_M4_32_g N005_32_M4_32_s VDD_M4_32_b pmos l=1u w=4u
R_VDD_M5_32_d VDD VDD_M5_32_d 0.01
R_B_32_M5_32_g B_32 B_32_M5_32_g 0.01
R_N001_32_M5_32_s N001_32 N001_32_M5_32_s 0.01
R_VDD_M5_32_b VDD VDD_M5_32_b 0.01
M5_32 VDD_M5_32_d B_32_M5_32_g N001_32_M5_32_s VDD_M5_32_b pmos l=1u w=4u
R_VDD_M6_32_d VDD VDD_M6_32_d 0.01
R_N005_32_M6_32_g N005_32 N005_32_M6_32_g 0.01
R_C_33_M6_32_s C_33 C_33_M6_32_s 0.01
R_VDD_M6_32_b VDD VDD_M6_32_b 0.01
M6_32 VDD_M6_32_d N005_32_M6_32_g C_33_M6_32_s VDD_M6_32_b pmos l=1u w=2u
R_VDD_M7_32_d VDD VDD_M7_32_d 0.01
R_A_32_M7_32_g A_32 A_32_M7_32_g 0.01
R_N002_32_M7_32_s N002_32 N002_32_M7_32_s 0.01
R_VDD_M7_32_b VDD VDD_M7_32_b 0.01
M7_32 VDD_M7_32_d A_32_M7_32_g N002_32_M7_32_s VDD_M7_32_b pmos l=1u w=4u
R_VDD_M8_32_d VDD VDD_M8_32_d 0.01
R_B_32_M8_32_g B_32 B_32_M8_32_g 0.01
R_N002_32_M8_32_s N002_32 N002_32_M8_32_s 0.01
R_VDD_M8_32_b VDD VDD_M8_32_b 0.01
M8_32 VDD_M8_32_d B_32_M8_32_g N002_32_M8_32_s VDD_M8_32_b pmos l=1u w=4u
R_VDD_M9_32_d VDD VDD_M9_32_d 0.01
R_C_32_M9_32_g C_32 C_32_M9_32_g 0.01
R_N002_32_M9_32_s N002_32 N002_32_M9_32_s 0.01
R_VDD_M9_32_b VDD VDD_M9_32_b 0.01
M9_32 VDD_M9_32_d C_32_M9_32_g N002_32_M9_32_s VDD_M9_32_b pmos l=1u w=4u
R_VDD_M10_32_d VDD VDD_M10_32_d 0.01
R_A_32_M10_32_g A_32 A_32_M10_32_g 0.01
R_N004_32_M10_32_s N004_32 N004_32_M10_32_s 0.01
R_VDD_M10_32_b VDD VDD_M10_32_b 0.01
M10_32 VDD_M10_32_d A_32_M10_32_g N004_32_M10_32_s VDD_M10_32_b pmos l=1u w=8u
R_N004_32_M11_32_d N004_32 N004_32_M11_32_d 0.01
R_B_32_M11_32_g B_32 B_32_M11_32_g 0.01
R_N006_32_M11_32_s N006_32 N006_32_M11_32_s 0.01
R_VDD_M11_32_b VDD VDD_M11_32_b 0.01
M11_32 N004_32_M11_32_d B_32_M11_32_g N006_32_M11_32_s VDD_M11_32_b pmos l=1u w=8u
R_N006_32_M12_32_d N006_32 N006_32_M12_32_d 0.01
R_C_32_M12_32_g C_32 C_32_M12_32_g 0.01
R_N007_32_M12_32_s N007_32 N007_32_M12_32_s 0.01
R_VDD_M12_32_b VDD VDD_M12_32_b 0.01
M12_32 N006_32_M12_32_d C_32_M12_32_g N007_32_M12_32_s VDD_M12_32_b pmos l=1u w=8u
R_N007_32_M13_32_d N007_32 N007_32_M13_32_d 0.01
R_C_32_M13_32_g C_32 C_32_M13_32_g 0.01
R_N008_32_M13_32_s N008_32 N008_32_M13_32_s 0.01
M13_32 N007_32_M13_32_d C_32_M13_32_g N008_32_M13_32_s 0 nmos l=1u w=8u
R_N008_32_M14_32_d N008_32 N008_32_M14_32_d 0.01
R_B_32_M14_32_g B_32 B_32_M14_32_g 0.01
R_N012_32_M14_32_s N012_32 N012_32_M14_32_s 0.01
M14_32 N008_32_M14_32_d B_32_M14_32_g N012_32_M14_32_s 0 nmos l=1u w=8u
R_N012_32_M15_32_d N012_32 N012_32_M15_32_d 0.01
R_A_32_M15_32_g A_32 A_32_M15_32_g 0.01
M15_32 N012_32_M15_32_d A_32_M15_32_g 0 0 nmos l=1u w=8u
R_N010_32_M16_32_d N010_32 N010_32_M16_32_d 0.01
R_C_32_M16_32_g C_32 C_32_M16_32_g 0.01
M16_32 N010_32_M16_32_d C_32_M16_32_g 0 0 nmos l=1u w=2u
R_N010_32_M17_32_d N010_32 N010_32_M17_32_d 0.01
R_B_32_M17_32_g B_32 B_32_M17_32_g 0.01
M17_32 N010_32_M17_32_d B_32_M17_32_g 0 0 nmos l=1u w=2u
R_N010_32_M18_32_d N010_32 N010_32_M18_32_d 0.01
R_A_32_M18_32_g A_32 A_32_M18_32_g 0.01
M18_32 N010_32_M18_32_d A_32_M18_32_g 0 0 nmos l=1u w=2u
R_N007_32_M19_32_d N007_32 N007_32_M19_32_d 0.01
R_N005_32_M19_32_g N005_32 N005_32_M19_32_g 0.01
R_N010_32_M19_32_s N010_32 N010_32_M19_32_s 0.01
M19_32 N007_32_M19_32_d N005_32_M19_32_g N010_32_M19_32_s 0 nmos l=1u w=2u
R_N009_32_M20_32_d N009_32 N009_32_M20_32_d 0.01
R_B_32_M20_32_g B_32 B_32_M20_32_g 0.01
M20_32 N009_32_M20_32_d B_32_M20_32_g 0 0 nmos l=1u w=2u
R_N009_32_M21_32_d N009_32 N009_32_M21_32_d 0.01
R_A_32_M21_32_g A_32 A_32_M21_32_g 0.01
M21_32 N009_32_M21_32_d A_32_M21_32_g 0 0 nmos l=1u w=2u
R_N011_32_M22_32_d N011_32 N011_32_M22_32_d 0.01
R_A_32_M22_32_g A_32 A_32_M22_32_g 0.01
M22_32 N011_32_M22_32_d A_32_M22_32_g 0 0 nmos l=1u w=2u
R_N005_32_M23_32_d N005_32 N005_32_M23_32_d 0.01
R_B_32_M23_32_g B_32 B_32_M23_32_g 0.01
R_N011_32_M23_32_s N011_32 N011_32_M23_32_s 0.01
M23_32 N005_32_M23_32_d B_32_M23_32_g N011_32_M23_32_s 0 nmos l=1u w=2u
R_N005_32_M24_32_d N005_32 N005_32_M24_32_d 0.01
R_C_32_M24_32_g C_32 C_32_M24_32_g 0.01
R_N009_32_M24_32_s N009_32 N009_32_M24_32_s 0.01
M24_32 N005_32_M24_32_d C_32_M24_32_g N009_32_M24_32_s 0 nmos l=1u w=2u
R_C_33_M25_32_d C_33 C_33_M25_32_d 0.01
R_N005_32_M25_32_g N005_32 N005_32_M25_32_g 0.01
M25_32 C_33_M25_32_d N005_32_M25_32_g 0 0 nmos l=1u w=1u
R_N002_32_M26_32_d N002_32 N002_32_M26_32_d 0.01
R_N005_32_M26_32_g N005_32 N005_32_M26_32_g 0.01
R_N007_32_M26_32_s N007_32 N007_32_M26_32_s 0.01
R_VDD_M26_32_b VDD VDD_M26_32_b 0.01
M26_32 N002_32_M26_32_d N005_32_M26_32_g N007_32_M26_32_s VDD_M26_32_b pmos l=1u w=4u
R_VDD_M27_32_d VDD VDD_M27_32_d 0.01
R_N007_32_M27_32_g N007_32 N007_32_M27_32_g 0.01
R_S_32_M27_32_s S_32 S_32_M27_32_s 0.01
R_VDD_M27_32_b VDD VDD_M27_32_b 0.01
M27_32 VDD_M27_32_d N007_32_M27_32_g S_32_M27_32_s VDD_M27_32_b pmos l=1u w=2u
R_S_32_M28_32_d S_32 S_32_M28_32_d 0.01
R_N007_32_M28_32_g N007_32 N007_32_M28_32_g 0.01
M28_32 S_32_M28_32_d N007_32_M28_32_g 0 0 nmos l=1u w=1u
C_S_32 S_32 0 1f
* --- Bit 33 ---
R_VDD_M1_33_d VDD VDD_M1_33_d 0.01
R_A_33_M1_33_g A_33 A_33_M1_33_g 0.01
R_N003_33_M1_33_s N003_33 N003_33_M1_33_s 0.01
R_VDD_M1_33_b VDD VDD_M1_33_b 0.01
M1_33 VDD_M1_33_d A_33_M1_33_g N003_33_M1_33_s VDD_M1_33_b pmos l=1u w=4u
R_N003_33_M2_33_d N003_33 N003_33_M2_33_d 0.01
R_B_33_M2_33_g B_33 B_33_M2_33_g 0.01
R_N005_33_M2_33_s N005_33 N005_33_M2_33_s 0.01
R_VDD_M2_33_b VDD VDD_M2_33_b 0.01
M2_33 N003_33_M2_33_d B_33_M2_33_g N005_33_M2_33_s VDD_M2_33_b pmos l=1u w=4u
R_VDD_M3_33_d VDD VDD_M3_33_d 0.01
R_A_33_M3_33_g A_33 A_33_M3_33_g 0.01
R_N001_33_M3_33_s N001_33 N001_33_M3_33_s 0.01
R_VDD_M3_33_b VDD VDD_M3_33_b 0.01
M3_33 VDD_M3_33_d A_33_M3_33_g N001_33_M3_33_s VDD_M3_33_b pmos l=1u w=4u
R_N001_33_M4_33_d N001_33 N001_33_M4_33_d 0.01
R_C_33_M4_33_g C_33 C_33_M4_33_g 0.01
R_N005_33_M4_33_s N005_33 N005_33_M4_33_s 0.01
R_VDD_M4_33_b VDD VDD_M4_33_b 0.01
M4_33 N001_33_M4_33_d C_33_M4_33_g N005_33_M4_33_s VDD_M4_33_b pmos l=1u w=4u
R_VDD_M5_33_d VDD VDD_M5_33_d 0.01
R_B_33_M5_33_g B_33 B_33_M5_33_g 0.01
R_N001_33_M5_33_s N001_33 N001_33_M5_33_s 0.01
R_VDD_M5_33_b VDD VDD_M5_33_b 0.01
M5_33 VDD_M5_33_d B_33_M5_33_g N001_33_M5_33_s VDD_M5_33_b pmos l=1u w=4u
R_VDD_M6_33_d VDD VDD_M6_33_d 0.01
R_N005_33_M6_33_g N005_33 N005_33_M6_33_g 0.01
R_C_34_M6_33_s C_34 C_34_M6_33_s 0.01
R_VDD_M6_33_b VDD VDD_M6_33_b 0.01
M6_33 VDD_M6_33_d N005_33_M6_33_g C_34_M6_33_s VDD_M6_33_b pmos l=1u w=2u
R_VDD_M7_33_d VDD VDD_M7_33_d 0.01
R_A_33_M7_33_g A_33 A_33_M7_33_g 0.01
R_N002_33_M7_33_s N002_33 N002_33_M7_33_s 0.01
R_VDD_M7_33_b VDD VDD_M7_33_b 0.01
M7_33 VDD_M7_33_d A_33_M7_33_g N002_33_M7_33_s VDD_M7_33_b pmos l=1u w=4u
R_VDD_M8_33_d VDD VDD_M8_33_d 0.01
R_B_33_M8_33_g B_33 B_33_M8_33_g 0.01
R_N002_33_M8_33_s N002_33 N002_33_M8_33_s 0.01
R_VDD_M8_33_b VDD VDD_M8_33_b 0.01
M8_33 VDD_M8_33_d B_33_M8_33_g N002_33_M8_33_s VDD_M8_33_b pmos l=1u w=4u
R_VDD_M9_33_d VDD VDD_M9_33_d 0.01
R_C_33_M9_33_g C_33 C_33_M9_33_g 0.01
R_N002_33_M9_33_s N002_33 N002_33_M9_33_s 0.01
R_VDD_M9_33_b VDD VDD_M9_33_b 0.01
M9_33 VDD_M9_33_d C_33_M9_33_g N002_33_M9_33_s VDD_M9_33_b pmos l=1u w=4u
R_VDD_M10_33_d VDD VDD_M10_33_d 0.01
R_A_33_M10_33_g A_33 A_33_M10_33_g 0.01
R_N004_33_M10_33_s N004_33 N004_33_M10_33_s 0.01
R_VDD_M10_33_b VDD VDD_M10_33_b 0.01
M10_33 VDD_M10_33_d A_33_M10_33_g N004_33_M10_33_s VDD_M10_33_b pmos l=1u w=8u
R_N004_33_M11_33_d N004_33 N004_33_M11_33_d 0.01
R_B_33_M11_33_g B_33 B_33_M11_33_g 0.01
R_N006_33_M11_33_s N006_33 N006_33_M11_33_s 0.01
R_VDD_M11_33_b VDD VDD_M11_33_b 0.01
M11_33 N004_33_M11_33_d B_33_M11_33_g N006_33_M11_33_s VDD_M11_33_b pmos l=1u w=8u
R_N006_33_M12_33_d N006_33 N006_33_M12_33_d 0.01
R_C_33_M12_33_g C_33 C_33_M12_33_g 0.01
R_N007_33_M12_33_s N007_33 N007_33_M12_33_s 0.01
R_VDD_M12_33_b VDD VDD_M12_33_b 0.01
M12_33 N006_33_M12_33_d C_33_M12_33_g N007_33_M12_33_s VDD_M12_33_b pmos l=1u w=8u
R_N007_33_M13_33_d N007_33 N007_33_M13_33_d 0.01
R_C_33_M13_33_g C_33 C_33_M13_33_g 0.01
R_N008_33_M13_33_s N008_33 N008_33_M13_33_s 0.01
M13_33 N007_33_M13_33_d C_33_M13_33_g N008_33_M13_33_s 0 nmos l=1u w=8u
R_N008_33_M14_33_d N008_33 N008_33_M14_33_d 0.01
R_B_33_M14_33_g B_33 B_33_M14_33_g 0.01
R_N012_33_M14_33_s N012_33 N012_33_M14_33_s 0.01
M14_33 N008_33_M14_33_d B_33_M14_33_g N012_33_M14_33_s 0 nmos l=1u w=8u
R_N012_33_M15_33_d N012_33 N012_33_M15_33_d 0.01
R_A_33_M15_33_g A_33 A_33_M15_33_g 0.01
M15_33 N012_33_M15_33_d A_33_M15_33_g 0 0 nmos l=1u w=8u
R_N010_33_M16_33_d N010_33 N010_33_M16_33_d 0.01
R_C_33_M16_33_g C_33 C_33_M16_33_g 0.01
M16_33 N010_33_M16_33_d C_33_M16_33_g 0 0 nmos l=1u w=2u
R_N010_33_M17_33_d N010_33 N010_33_M17_33_d 0.01
R_B_33_M17_33_g B_33 B_33_M17_33_g 0.01
M17_33 N010_33_M17_33_d B_33_M17_33_g 0 0 nmos l=1u w=2u
R_N010_33_M18_33_d N010_33 N010_33_M18_33_d 0.01
R_A_33_M18_33_g A_33 A_33_M18_33_g 0.01
M18_33 N010_33_M18_33_d A_33_M18_33_g 0 0 nmos l=1u w=2u
R_N007_33_M19_33_d N007_33 N007_33_M19_33_d 0.01
R_N005_33_M19_33_g N005_33 N005_33_M19_33_g 0.01
R_N010_33_M19_33_s N010_33 N010_33_M19_33_s 0.01
M19_33 N007_33_M19_33_d N005_33_M19_33_g N010_33_M19_33_s 0 nmos l=1u w=2u
R_N009_33_M20_33_d N009_33 N009_33_M20_33_d 0.01
R_B_33_M20_33_g B_33 B_33_M20_33_g 0.01
M20_33 N009_33_M20_33_d B_33_M20_33_g 0 0 nmos l=1u w=2u
R_N009_33_M21_33_d N009_33 N009_33_M21_33_d 0.01
R_A_33_M21_33_g A_33 A_33_M21_33_g 0.01
M21_33 N009_33_M21_33_d A_33_M21_33_g 0 0 nmos l=1u w=2u
R_N011_33_M22_33_d N011_33 N011_33_M22_33_d 0.01
R_A_33_M22_33_g A_33 A_33_M22_33_g 0.01
M22_33 N011_33_M22_33_d A_33_M22_33_g 0 0 nmos l=1u w=2u
R_N005_33_M23_33_d N005_33 N005_33_M23_33_d 0.01
R_B_33_M23_33_g B_33 B_33_M23_33_g 0.01
R_N011_33_M23_33_s N011_33 N011_33_M23_33_s 0.01
M23_33 N005_33_M23_33_d B_33_M23_33_g N011_33_M23_33_s 0 nmos l=1u w=2u
R_N005_33_M24_33_d N005_33 N005_33_M24_33_d 0.01
R_C_33_M24_33_g C_33 C_33_M24_33_g 0.01
R_N009_33_M24_33_s N009_33 N009_33_M24_33_s 0.01
M24_33 N005_33_M24_33_d C_33_M24_33_g N009_33_M24_33_s 0 nmos l=1u w=2u
R_C_34_M25_33_d C_34 C_34_M25_33_d 0.01
R_N005_33_M25_33_g N005_33 N005_33_M25_33_g 0.01
M25_33 C_34_M25_33_d N005_33_M25_33_g 0 0 nmos l=1u w=1u
R_N002_33_M26_33_d N002_33 N002_33_M26_33_d 0.01
R_N005_33_M26_33_g N005_33 N005_33_M26_33_g 0.01
R_N007_33_M26_33_s N007_33 N007_33_M26_33_s 0.01
R_VDD_M26_33_b VDD VDD_M26_33_b 0.01
M26_33 N002_33_M26_33_d N005_33_M26_33_g N007_33_M26_33_s VDD_M26_33_b pmos l=1u w=4u
R_VDD_M27_33_d VDD VDD_M27_33_d 0.01
R_N007_33_M27_33_g N007_33 N007_33_M27_33_g 0.01
R_S_33_M27_33_s S_33 S_33_M27_33_s 0.01
R_VDD_M27_33_b VDD VDD_M27_33_b 0.01
M27_33 VDD_M27_33_d N007_33_M27_33_g S_33_M27_33_s VDD_M27_33_b pmos l=1u w=2u
R_S_33_M28_33_d S_33 S_33_M28_33_d 0.01
R_N007_33_M28_33_g N007_33 N007_33_M28_33_g 0.01
M28_33 S_33_M28_33_d N007_33_M28_33_g 0 0 nmos l=1u w=1u
C_S_33 S_33 0 1f
* --- Bit 34 ---
R_VDD_M1_34_d VDD VDD_M1_34_d 0.01
R_A_34_M1_34_g A_34 A_34_M1_34_g 0.01
R_N003_34_M1_34_s N003_34 N003_34_M1_34_s 0.01
R_VDD_M1_34_b VDD VDD_M1_34_b 0.01
M1_34 VDD_M1_34_d A_34_M1_34_g N003_34_M1_34_s VDD_M1_34_b pmos l=1u w=4u
R_N003_34_M2_34_d N003_34 N003_34_M2_34_d 0.01
R_B_34_M2_34_g B_34 B_34_M2_34_g 0.01
R_N005_34_M2_34_s N005_34 N005_34_M2_34_s 0.01
R_VDD_M2_34_b VDD VDD_M2_34_b 0.01
M2_34 N003_34_M2_34_d B_34_M2_34_g N005_34_M2_34_s VDD_M2_34_b pmos l=1u w=4u
R_VDD_M3_34_d VDD VDD_M3_34_d 0.01
R_A_34_M3_34_g A_34 A_34_M3_34_g 0.01
R_N001_34_M3_34_s N001_34 N001_34_M3_34_s 0.01
R_VDD_M3_34_b VDD VDD_M3_34_b 0.01
M3_34 VDD_M3_34_d A_34_M3_34_g N001_34_M3_34_s VDD_M3_34_b pmos l=1u w=4u
R_N001_34_M4_34_d N001_34 N001_34_M4_34_d 0.01
R_C_34_M4_34_g C_34 C_34_M4_34_g 0.01
R_N005_34_M4_34_s N005_34 N005_34_M4_34_s 0.01
R_VDD_M4_34_b VDD VDD_M4_34_b 0.01
M4_34 N001_34_M4_34_d C_34_M4_34_g N005_34_M4_34_s VDD_M4_34_b pmos l=1u w=4u
R_VDD_M5_34_d VDD VDD_M5_34_d 0.01
R_B_34_M5_34_g B_34 B_34_M5_34_g 0.01
R_N001_34_M5_34_s N001_34 N001_34_M5_34_s 0.01
R_VDD_M5_34_b VDD VDD_M5_34_b 0.01
M5_34 VDD_M5_34_d B_34_M5_34_g N001_34_M5_34_s VDD_M5_34_b pmos l=1u w=4u
R_VDD_M6_34_d VDD VDD_M6_34_d 0.01
R_N005_34_M6_34_g N005_34 N005_34_M6_34_g 0.01
R_C_35_M6_34_s C_35 C_35_M6_34_s 0.01
R_VDD_M6_34_b VDD VDD_M6_34_b 0.01
M6_34 VDD_M6_34_d N005_34_M6_34_g C_35_M6_34_s VDD_M6_34_b pmos l=1u w=2u
R_VDD_M7_34_d VDD VDD_M7_34_d 0.01
R_A_34_M7_34_g A_34 A_34_M7_34_g 0.01
R_N002_34_M7_34_s N002_34 N002_34_M7_34_s 0.01
R_VDD_M7_34_b VDD VDD_M7_34_b 0.01
M7_34 VDD_M7_34_d A_34_M7_34_g N002_34_M7_34_s VDD_M7_34_b pmos l=1u w=4u
R_VDD_M8_34_d VDD VDD_M8_34_d 0.01
R_B_34_M8_34_g B_34 B_34_M8_34_g 0.01
R_N002_34_M8_34_s N002_34 N002_34_M8_34_s 0.01
R_VDD_M8_34_b VDD VDD_M8_34_b 0.01
M8_34 VDD_M8_34_d B_34_M8_34_g N002_34_M8_34_s VDD_M8_34_b pmos l=1u w=4u
R_VDD_M9_34_d VDD VDD_M9_34_d 0.01
R_C_34_M9_34_g C_34 C_34_M9_34_g 0.01
R_N002_34_M9_34_s N002_34 N002_34_M9_34_s 0.01
R_VDD_M9_34_b VDD VDD_M9_34_b 0.01
M9_34 VDD_M9_34_d C_34_M9_34_g N002_34_M9_34_s VDD_M9_34_b pmos l=1u w=4u
R_VDD_M10_34_d VDD VDD_M10_34_d 0.01
R_A_34_M10_34_g A_34 A_34_M10_34_g 0.01
R_N004_34_M10_34_s N004_34 N004_34_M10_34_s 0.01
R_VDD_M10_34_b VDD VDD_M10_34_b 0.01
M10_34 VDD_M10_34_d A_34_M10_34_g N004_34_M10_34_s VDD_M10_34_b pmos l=1u w=8u
R_N004_34_M11_34_d N004_34 N004_34_M11_34_d 0.01
R_B_34_M11_34_g B_34 B_34_M11_34_g 0.01
R_N006_34_M11_34_s N006_34 N006_34_M11_34_s 0.01
R_VDD_M11_34_b VDD VDD_M11_34_b 0.01
M11_34 N004_34_M11_34_d B_34_M11_34_g N006_34_M11_34_s VDD_M11_34_b pmos l=1u w=8u
R_N006_34_M12_34_d N006_34 N006_34_M12_34_d 0.01
R_C_34_M12_34_g C_34 C_34_M12_34_g 0.01
R_N007_34_M12_34_s N007_34 N007_34_M12_34_s 0.01
R_VDD_M12_34_b VDD VDD_M12_34_b 0.01
M12_34 N006_34_M12_34_d C_34_M12_34_g N007_34_M12_34_s VDD_M12_34_b pmos l=1u w=8u
R_N007_34_M13_34_d N007_34 N007_34_M13_34_d 0.01
R_C_34_M13_34_g C_34 C_34_M13_34_g 0.01
R_N008_34_M13_34_s N008_34 N008_34_M13_34_s 0.01
M13_34 N007_34_M13_34_d C_34_M13_34_g N008_34_M13_34_s 0 nmos l=1u w=8u
R_N008_34_M14_34_d N008_34 N008_34_M14_34_d 0.01
R_B_34_M14_34_g B_34 B_34_M14_34_g 0.01
R_N012_34_M14_34_s N012_34 N012_34_M14_34_s 0.01
M14_34 N008_34_M14_34_d B_34_M14_34_g N012_34_M14_34_s 0 nmos l=1u w=8u
R_N012_34_M15_34_d N012_34 N012_34_M15_34_d 0.01
R_A_34_M15_34_g A_34 A_34_M15_34_g 0.01
M15_34 N012_34_M15_34_d A_34_M15_34_g 0 0 nmos l=1u w=8u
R_N010_34_M16_34_d N010_34 N010_34_M16_34_d 0.01
R_C_34_M16_34_g C_34 C_34_M16_34_g 0.01
M16_34 N010_34_M16_34_d C_34_M16_34_g 0 0 nmos l=1u w=2u
R_N010_34_M17_34_d N010_34 N010_34_M17_34_d 0.01
R_B_34_M17_34_g B_34 B_34_M17_34_g 0.01
M17_34 N010_34_M17_34_d B_34_M17_34_g 0 0 nmos l=1u w=2u
R_N010_34_M18_34_d N010_34 N010_34_M18_34_d 0.01
R_A_34_M18_34_g A_34 A_34_M18_34_g 0.01
M18_34 N010_34_M18_34_d A_34_M18_34_g 0 0 nmos l=1u w=2u
R_N007_34_M19_34_d N007_34 N007_34_M19_34_d 0.01
R_N005_34_M19_34_g N005_34 N005_34_M19_34_g 0.01
R_N010_34_M19_34_s N010_34 N010_34_M19_34_s 0.01
M19_34 N007_34_M19_34_d N005_34_M19_34_g N010_34_M19_34_s 0 nmos l=1u w=2u
R_N009_34_M20_34_d N009_34 N009_34_M20_34_d 0.01
R_B_34_M20_34_g B_34 B_34_M20_34_g 0.01
M20_34 N009_34_M20_34_d B_34_M20_34_g 0 0 nmos l=1u w=2u
R_N009_34_M21_34_d N009_34 N009_34_M21_34_d 0.01
R_A_34_M21_34_g A_34 A_34_M21_34_g 0.01
M21_34 N009_34_M21_34_d A_34_M21_34_g 0 0 nmos l=1u w=2u
R_N011_34_M22_34_d N011_34 N011_34_M22_34_d 0.01
R_A_34_M22_34_g A_34 A_34_M22_34_g 0.01
M22_34 N011_34_M22_34_d A_34_M22_34_g 0 0 nmos l=1u w=2u
R_N005_34_M23_34_d N005_34 N005_34_M23_34_d 0.01
R_B_34_M23_34_g B_34 B_34_M23_34_g 0.01
R_N011_34_M23_34_s N011_34 N011_34_M23_34_s 0.01
M23_34 N005_34_M23_34_d B_34_M23_34_g N011_34_M23_34_s 0 nmos l=1u w=2u
R_N005_34_M24_34_d N005_34 N005_34_M24_34_d 0.01
R_C_34_M24_34_g C_34 C_34_M24_34_g 0.01
R_N009_34_M24_34_s N009_34 N009_34_M24_34_s 0.01
M24_34 N005_34_M24_34_d C_34_M24_34_g N009_34_M24_34_s 0 nmos l=1u w=2u
R_C_35_M25_34_d C_35 C_35_M25_34_d 0.01
R_N005_34_M25_34_g N005_34 N005_34_M25_34_g 0.01
M25_34 C_35_M25_34_d N005_34_M25_34_g 0 0 nmos l=1u w=1u
R_N002_34_M26_34_d N002_34 N002_34_M26_34_d 0.01
R_N005_34_M26_34_g N005_34 N005_34_M26_34_g 0.01
R_N007_34_M26_34_s N007_34 N007_34_M26_34_s 0.01
R_VDD_M26_34_b VDD VDD_M26_34_b 0.01
M26_34 N002_34_M26_34_d N005_34_M26_34_g N007_34_M26_34_s VDD_M26_34_b pmos l=1u w=4u
R_VDD_M27_34_d VDD VDD_M27_34_d 0.01
R_N007_34_M27_34_g N007_34 N007_34_M27_34_g 0.01
R_S_34_M27_34_s S_34 S_34_M27_34_s 0.01
R_VDD_M27_34_b VDD VDD_M27_34_b 0.01
M27_34 VDD_M27_34_d N007_34_M27_34_g S_34_M27_34_s VDD_M27_34_b pmos l=1u w=2u
R_S_34_M28_34_d S_34 S_34_M28_34_d 0.01
R_N007_34_M28_34_g N007_34 N007_34_M28_34_g 0.01
M28_34 S_34_M28_34_d N007_34_M28_34_g 0 0 nmos l=1u w=1u
C_S_34 S_34 0 1f
* --- Bit 35 ---
R_VDD_M1_35_d VDD VDD_M1_35_d 0.01
R_A_35_M1_35_g A_35 A_35_M1_35_g 0.01
R_N003_35_M1_35_s N003_35 N003_35_M1_35_s 0.01
R_VDD_M1_35_b VDD VDD_M1_35_b 0.01
M1_35 VDD_M1_35_d A_35_M1_35_g N003_35_M1_35_s VDD_M1_35_b pmos l=1u w=4u
R_N003_35_M2_35_d N003_35 N003_35_M2_35_d 0.01
R_B_35_M2_35_g B_35 B_35_M2_35_g 0.01
R_N005_35_M2_35_s N005_35 N005_35_M2_35_s 0.01
R_VDD_M2_35_b VDD VDD_M2_35_b 0.01
M2_35 N003_35_M2_35_d B_35_M2_35_g N005_35_M2_35_s VDD_M2_35_b pmos l=1u w=4u
R_VDD_M3_35_d VDD VDD_M3_35_d 0.01
R_A_35_M3_35_g A_35 A_35_M3_35_g 0.01
R_N001_35_M3_35_s N001_35 N001_35_M3_35_s 0.01
R_VDD_M3_35_b VDD VDD_M3_35_b 0.01
M3_35 VDD_M3_35_d A_35_M3_35_g N001_35_M3_35_s VDD_M3_35_b pmos l=1u w=4u
R_N001_35_M4_35_d N001_35 N001_35_M4_35_d 0.01
R_C_35_M4_35_g C_35 C_35_M4_35_g 0.01
R_N005_35_M4_35_s N005_35 N005_35_M4_35_s 0.01
R_VDD_M4_35_b VDD VDD_M4_35_b 0.01
M4_35 N001_35_M4_35_d C_35_M4_35_g N005_35_M4_35_s VDD_M4_35_b pmos l=1u w=4u
R_VDD_M5_35_d VDD VDD_M5_35_d 0.01
R_B_35_M5_35_g B_35 B_35_M5_35_g 0.01
R_N001_35_M5_35_s N001_35 N001_35_M5_35_s 0.01
R_VDD_M5_35_b VDD VDD_M5_35_b 0.01
M5_35 VDD_M5_35_d B_35_M5_35_g N001_35_M5_35_s VDD_M5_35_b pmos l=1u w=4u
R_VDD_M6_35_d VDD VDD_M6_35_d 0.01
R_N005_35_M6_35_g N005_35 N005_35_M6_35_g 0.01
R_C_36_M6_35_s C_36 C_36_M6_35_s 0.01
R_VDD_M6_35_b VDD VDD_M6_35_b 0.01
M6_35 VDD_M6_35_d N005_35_M6_35_g C_36_M6_35_s VDD_M6_35_b pmos l=1u w=2u
R_VDD_M7_35_d VDD VDD_M7_35_d 0.01
R_A_35_M7_35_g A_35 A_35_M7_35_g 0.01
R_N002_35_M7_35_s N002_35 N002_35_M7_35_s 0.01
R_VDD_M7_35_b VDD VDD_M7_35_b 0.01
M7_35 VDD_M7_35_d A_35_M7_35_g N002_35_M7_35_s VDD_M7_35_b pmos l=1u w=4u
R_VDD_M8_35_d VDD VDD_M8_35_d 0.01
R_B_35_M8_35_g B_35 B_35_M8_35_g 0.01
R_N002_35_M8_35_s N002_35 N002_35_M8_35_s 0.01
R_VDD_M8_35_b VDD VDD_M8_35_b 0.01
M8_35 VDD_M8_35_d B_35_M8_35_g N002_35_M8_35_s VDD_M8_35_b pmos l=1u w=4u
R_VDD_M9_35_d VDD VDD_M9_35_d 0.01
R_C_35_M9_35_g C_35 C_35_M9_35_g 0.01
R_N002_35_M9_35_s N002_35 N002_35_M9_35_s 0.01
R_VDD_M9_35_b VDD VDD_M9_35_b 0.01
M9_35 VDD_M9_35_d C_35_M9_35_g N002_35_M9_35_s VDD_M9_35_b pmos l=1u w=4u
R_VDD_M10_35_d VDD VDD_M10_35_d 0.01
R_A_35_M10_35_g A_35 A_35_M10_35_g 0.01
R_N004_35_M10_35_s N004_35 N004_35_M10_35_s 0.01
R_VDD_M10_35_b VDD VDD_M10_35_b 0.01
M10_35 VDD_M10_35_d A_35_M10_35_g N004_35_M10_35_s VDD_M10_35_b pmos l=1u w=8u
R_N004_35_M11_35_d N004_35 N004_35_M11_35_d 0.01
R_B_35_M11_35_g B_35 B_35_M11_35_g 0.01
R_N006_35_M11_35_s N006_35 N006_35_M11_35_s 0.01
R_VDD_M11_35_b VDD VDD_M11_35_b 0.01
M11_35 N004_35_M11_35_d B_35_M11_35_g N006_35_M11_35_s VDD_M11_35_b pmos l=1u w=8u
R_N006_35_M12_35_d N006_35 N006_35_M12_35_d 0.01
R_C_35_M12_35_g C_35 C_35_M12_35_g 0.01
R_N007_35_M12_35_s N007_35 N007_35_M12_35_s 0.01
R_VDD_M12_35_b VDD VDD_M12_35_b 0.01
M12_35 N006_35_M12_35_d C_35_M12_35_g N007_35_M12_35_s VDD_M12_35_b pmos l=1u w=8u
R_N007_35_M13_35_d N007_35 N007_35_M13_35_d 0.01
R_C_35_M13_35_g C_35 C_35_M13_35_g 0.01
R_N008_35_M13_35_s N008_35 N008_35_M13_35_s 0.01
M13_35 N007_35_M13_35_d C_35_M13_35_g N008_35_M13_35_s 0 nmos l=1u w=8u
R_N008_35_M14_35_d N008_35 N008_35_M14_35_d 0.01
R_B_35_M14_35_g B_35 B_35_M14_35_g 0.01
R_N012_35_M14_35_s N012_35 N012_35_M14_35_s 0.01
M14_35 N008_35_M14_35_d B_35_M14_35_g N012_35_M14_35_s 0 nmos l=1u w=8u
R_N012_35_M15_35_d N012_35 N012_35_M15_35_d 0.01
R_A_35_M15_35_g A_35 A_35_M15_35_g 0.01
M15_35 N012_35_M15_35_d A_35_M15_35_g 0 0 nmos l=1u w=8u
R_N010_35_M16_35_d N010_35 N010_35_M16_35_d 0.01
R_C_35_M16_35_g C_35 C_35_M16_35_g 0.01
M16_35 N010_35_M16_35_d C_35_M16_35_g 0 0 nmos l=1u w=2u
R_N010_35_M17_35_d N010_35 N010_35_M17_35_d 0.01
R_B_35_M17_35_g B_35 B_35_M17_35_g 0.01
M17_35 N010_35_M17_35_d B_35_M17_35_g 0 0 nmos l=1u w=2u
R_N010_35_M18_35_d N010_35 N010_35_M18_35_d 0.01
R_A_35_M18_35_g A_35 A_35_M18_35_g 0.01
M18_35 N010_35_M18_35_d A_35_M18_35_g 0 0 nmos l=1u w=2u
R_N007_35_M19_35_d N007_35 N007_35_M19_35_d 0.01
R_N005_35_M19_35_g N005_35 N005_35_M19_35_g 0.01
R_N010_35_M19_35_s N010_35 N010_35_M19_35_s 0.01
M19_35 N007_35_M19_35_d N005_35_M19_35_g N010_35_M19_35_s 0 nmos l=1u w=2u
R_N009_35_M20_35_d N009_35 N009_35_M20_35_d 0.01
R_B_35_M20_35_g B_35 B_35_M20_35_g 0.01
M20_35 N009_35_M20_35_d B_35_M20_35_g 0 0 nmos l=1u w=2u
R_N009_35_M21_35_d N009_35 N009_35_M21_35_d 0.01
R_A_35_M21_35_g A_35 A_35_M21_35_g 0.01
M21_35 N009_35_M21_35_d A_35_M21_35_g 0 0 nmos l=1u w=2u
R_N011_35_M22_35_d N011_35 N011_35_M22_35_d 0.01
R_A_35_M22_35_g A_35 A_35_M22_35_g 0.01
M22_35 N011_35_M22_35_d A_35_M22_35_g 0 0 nmos l=1u w=2u
R_N005_35_M23_35_d N005_35 N005_35_M23_35_d 0.01
R_B_35_M23_35_g B_35 B_35_M23_35_g 0.01
R_N011_35_M23_35_s N011_35 N011_35_M23_35_s 0.01
M23_35 N005_35_M23_35_d B_35_M23_35_g N011_35_M23_35_s 0 nmos l=1u w=2u
R_N005_35_M24_35_d N005_35 N005_35_M24_35_d 0.01
R_C_35_M24_35_g C_35 C_35_M24_35_g 0.01
R_N009_35_M24_35_s N009_35 N009_35_M24_35_s 0.01
M24_35 N005_35_M24_35_d C_35_M24_35_g N009_35_M24_35_s 0 nmos l=1u w=2u
R_C_36_M25_35_d C_36 C_36_M25_35_d 0.01
R_N005_35_M25_35_g N005_35 N005_35_M25_35_g 0.01
M25_35 C_36_M25_35_d N005_35_M25_35_g 0 0 nmos l=1u w=1u
R_N002_35_M26_35_d N002_35 N002_35_M26_35_d 0.01
R_N005_35_M26_35_g N005_35 N005_35_M26_35_g 0.01
R_N007_35_M26_35_s N007_35 N007_35_M26_35_s 0.01
R_VDD_M26_35_b VDD VDD_M26_35_b 0.01
M26_35 N002_35_M26_35_d N005_35_M26_35_g N007_35_M26_35_s VDD_M26_35_b pmos l=1u w=4u
R_VDD_M27_35_d VDD VDD_M27_35_d 0.01
R_N007_35_M27_35_g N007_35 N007_35_M27_35_g 0.01
R_S_35_M27_35_s S_35 S_35_M27_35_s 0.01
R_VDD_M27_35_b VDD VDD_M27_35_b 0.01
M27_35 VDD_M27_35_d N007_35_M27_35_g S_35_M27_35_s VDD_M27_35_b pmos l=1u w=2u
R_S_35_M28_35_d S_35 S_35_M28_35_d 0.01
R_N007_35_M28_35_g N007_35 N007_35_M28_35_g 0.01
M28_35 S_35_M28_35_d N007_35_M28_35_g 0 0 nmos l=1u w=1u
C_S_35 S_35 0 1f
* --- Bit 36 ---
R_VDD_M1_36_d VDD VDD_M1_36_d 0.01
R_A_36_M1_36_g A_36 A_36_M1_36_g 0.01
R_N003_36_M1_36_s N003_36 N003_36_M1_36_s 0.01
R_VDD_M1_36_b VDD VDD_M1_36_b 0.01
M1_36 VDD_M1_36_d A_36_M1_36_g N003_36_M1_36_s VDD_M1_36_b pmos l=1u w=4u
R_N003_36_M2_36_d N003_36 N003_36_M2_36_d 0.01
R_B_36_M2_36_g B_36 B_36_M2_36_g 0.01
R_N005_36_M2_36_s N005_36 N005_36_M2_36_s 0.01
R_VDD_M2_36_b VDD VDD_M2_36_b 0.01
M2_36 N003_36_M2_36_d B_36_M2_36_g N005_36_M2_36_s VDD_M2_36_b pmos l=1u w=4u
R_VDD_M3_36_d VDD VDD_M3_36_d 0.01
R_A_36_M3_36_g A_36 A_36_M3_36_g 0.01
R_N001_36_M3_36_s N001_36 N001_36_M3_36_s 0.01
R_VDD_M3_36_b VDD VDD_M3_36_b 0.01
M3_36 VDD_M3_36_d A_36_M3_36_g N001_36_M3_36_s VDD_M3_36_b pmos l=1u w=4u
R_N001_36_M4_36_d N001_36 N001_36_M4_36_d 0.01
R_C_36_M4_36_g C_36 C_36_M4_36_g 0.01
R_N005_36_M4_36_s N005_36 N005_36_M4_36_s 0.01
R_VDD_M4_36_b VDD VDD_M4_36_b 0.01
M4_36 N001_36_M4_36_d C_36_M4_36_g N005_36_M4_36_s VDD_M4_36_b pmos l=1u w=4u
R_VDD_M5_36_d VDD VDD_M5_36_d 0.01
R_B_36_M5_36_g B_36 B_36_M5_36_g 0.01
R_N001_36_M5_36_s N001_36 N001_36_M5_36_s 0.01
R_VDD_M5_36_b VDD VDD_M5_36_b 0.01
M5_36 VDD_M5_36_d B_36_M5_36_g N001_36_M5_36_s VDD_M5_36_b pmos l=1u w=4u
R_VDD_M6_36_d VDD VDD_M6_36_d 0.01
R_N005_36_M6_36_g N005_36 N005_36_M6_36_g 0.01
R_C_37_M6_36_s C_37 C_37_M6_36_s 0.01
R_VDD_M6_36_b VDD VDD_M6_36_b 0.01
M6_36 VDD_M6_36_d N005_36_M6_36_g C_37_M6_36_s VDD_M6_36_b pmos l=1u w=2u
R_VDD_M7_36_d VDD VDD_M7_36_d 0.01
R_A_36_M7_36_g A_36 A_36_M7_36_g 0.01
R_N002_36_M7_36_s N002_36 N002_36_M7_36_s 0.01
R_VDD_M7_36_b VDD VDD_M7_36_b 0.01
M7_36 VDD_M7_36_d A_36_M7_36_g N002_36_M7_36_s VDD_M7_36_b pmos l=1u w=4u
R_VDD_M8_36_d VDD VDD_M8_36_d 0.01
R_B_36_M8_36_g B_36 B_36_M8_36_g 0.01
R_N002_36_M8_36_s N002_36 N002_36_M8_36_s 0.01
R_VDD_M8_36_b VDD VDD_M8_36_b 0.01
M8_36 VDD_M8_36_d B_36_M8_36_g N002_36_M8_36_s VDD_M8_36_b pmos l=1u w=4u
R_VDD_M9_36_d VDD VDD_M9_36_d 0.01
R_C_36_M9_36_g C_36 C_36_M9_36_g 0.01
R_N002_36_M9_36_s N002_36 N002_36_M9_36_s 0.01
R_VDD_M9_36_b VDD VDD_M9_36_b 0.01
M9_36 VDD_M9_36_d C_36_M9_36_g N002_36_M9_36_s VDD_M9_36_b pmos l=1u w=4u
R_VDD_M10_36_d VDD VDD_M10_36_d 0.01
R_A_36_M10_36_g A_36 A_36_M10_36_g 0.01
R_N004_36_M10_36_s N004_36 N004_36_M10_36_s 0.01
R_VDD_M10_36_b VDD VDD_M10_36_b 0.01
M10_36 VDD_M10_36_d A_36_M10_36_g N004_36_M10_36_s VDD_M10_36_b pmos l=1u w=8u
R_N004_36_M11_36_d N004_36 N004_36_M11_36_d 0.01
R_B_36_M11_36_g B_36 B_36_M11_36_g 0.01
R_N006_36_M11_36_s N006_36 N006_36_M11_36_s 0.01
R_VDD_M11_36_b VDD VDD_M11_36_b 0.01
M11_36 N004_36_M11_36_d B_36_M11_36_g N006_36_M11_36_s VDD_M11_36_b pmos l=1u w=8u
R_N006_36_M12_36_d N006_36 N006_36_M12_36_d 0.01
R_C_36_M12_36_g C_36 C_36_M12_36_g 0.01
R_N007_36_M12_36_s N007_36 N007_36_M12_36_s 0.01
R_VDD_M12_36_b VDD VDD_M12_36_b 0.01
M12_36 N006_36_M12_36_d C_36_M12_36_g N007_36_M12_36_s VDD_M12_36_b pmos l=1u w=8u
R_N007_36_M13_36_d N007_36 N007_36_M13_36_d 0.01
R_C_36_M13_36_g C_36 C_36_M13_36_g 0.01
R_N008_36_M13_36_s N008_36 N008_36_M13_36_s 0.01
M13_36 N007_36_M13_36_d C_36_M13_36_g N008_36_M13_36_s 0 nmos l=1u w=8u
R_N008_36_M14_36_d N008_36 N008_36_M14_36_d 0.01
R_B_36_M14_36_g B_36 B_36_M14_36_g 0.01
R_N012_36_M14_36_s N012_36 N012_36_M14_36_s 0.01
M14_36 N008_36_M14_36_d B_36_M14_36_g N012_36_M14_36_s 0 nmos l=1u w=8u
R_N012_36_M15_36_d N012_36 N012_36_M15_36_d 0.01
R_A_36_M15_36_g A_36 A_36_M15_36_g 0.01
M15_36 N012_36_M15_36_d A_36_M15_36_g 0 0 nmos l=1u w=8u
R_N010_36_M16_36_d N010_36 N010_36_M16_36_d 0.01
R_C_36_M16_36_g C_36 C_36_M16_36_g 0.01
M16_36 N010_36_M16_36_d C_36_M16_36_g 0 0 nmos l=1u w=2u
R_N010_36_M17_36_d N010_36 N010_36_M17_36_d 0.01
R_B_36_M17_36_g B_36 B_36_M17_36_g 0.01
M17_36 N010_36_M17_36_d B_36_M17_36_g 0 0 nmos l=1u w=2u
R_N010_36_M18_36_d N010_36 N010_36_M18_36_d 0.01
R_A_36_M18_36_g A_36 A_36_M18_36_g 0.01
M18_36 N010_36_M18_36_d A_36_M18_36_g 0 0 nmos l=1u w=2u
R_N007_36_M19_36_d N007_36 N007_36_M19_36_d 0.01
R_N005_36_M19_36_g N005_36 N005_36_M19_36_g 0.01
R_N010_36_M19_36_s N010_36 N010_36_M19_36_s 0.01
M19_36 N007_36_M19_36_d N005_36_M19_36_g N010_36_M19_36_s 0 nmos l=1u w=2u
R_N009_36_M20_36_d N009_36 N009_36_M20_36_d 0.01
R_B_36_M20_36_g B_36 B_36_M20_36_g 0.01
M20_36 N009_36_M20_36_d B_36_M20_36_g 0 0 nmos l=1u w=2u
R_N009_36_M21_36_d N009_36 N009_36_M21_36_d 0.01
R_A_36_M21_36_g A_36 A_36_M21_36_g 0.01
M21_36 N009_36_M21_36_d A_36_M21_36_g 0 0 nmos l=1u w=2u
R_N011_36_M22_36_d N011_36 N011_36_M22_36_d 0.01
R_A_36_M22_36_g A_36 A_36_M22_36_g 0.01
M22_36 N011_36_M22_36_d A_36_M22_36_g 0 0 nmos l=1u w=2u
R_N005_36_M23_36_d N005_36 N005_36_M23_36_d 0.01
R_B_36_M23_36_g B_36 B_36_M23_36_g 0.01
R_N011_36_M23_36_s N011_36 N011_36_M23_36_s 0.01
M23_36 N005_36_M23_36_d B_36_M23_36_g N011_36_M23_36_s 0 nmos l=1u w=2u
R_N005_36_M24_36_d N005_36 N005_36_M24_36_d 0.01
R_C_36_M24_36_g C_36 C_36_M24_36_g 0.01
R_N009_36_M24_36_s N009_36 N009_36_M24_36_s 0.01
M24_36 N005_36_M24_36_d C_36_M24_36_g N009_36_M24_36_s 0 nmos l=1u w=2u
R_C_37_M25_36_d C_37 C_37_M25_36_d 0.01
R_N005_36_M25_36_g N005_36 N005_36_M25_36_g 0.01
M25_36 C_37_M25_36_d N005_36_M25_36_g 0 0 nmos l=1u w=1u
R_N002_36_M26_36_d N002_36 N002_36_M26_36_d 0.01
R_N005_36_M26_36_g N005_36 N005_36_M26_36_g 0.01
R_N007_36_M26_36_s N007_36 N007_36_M26_36_s 0.01
R_VDD_M26_36_b VDD VDD_M26_36_b 0.01
M26_36 N002_36_M26_36_d N005_36_M26_36_g N007_36_M26_36_s VDD_M26_36_b pmos l=1u w=4u
R_VDD_M27_36_d VDD VDD_M27_36_d 0.01
R_N007_36_M27_36_g N007_36 N007_36_M27_36_g 0.01
R_S_36_M27_36_s S_36 S_36_M27_36_s 0.01
R_VDD_M27_36_b VDD VDD_M27_36_b 0.01
M27_36 VDD_M27_36_d N007_36_M27_36_g S_36_M27_36_s VDD_M27_36_b pmos l=1u w=2u
R_S_36_M28_36_d S_36 S_36_M28_36_d 0.01
R_N007_36_M28_36_g N007_36 N007_36_M28_36_g 0.01
M28_36 S_36_M28_36_d N007_36_M28_36_g 0 0 nmos l=1u w=1u
C_S_36 S_36 0 1f
* --- Bit 37 ---
R_VDD_M1_37_d VDD VDD_M1_37_d 0.01
R_A_37_M1_37_g A_37 A_37_M1_37_g 0.01
R_N003_37_M1_37_s N003_37 N003_37_M1_37_s 0.01
R_VDD_M1_37_b VDD VDD_M1_37_b 0.01
M1_37 VDD_M1_37_d A_37_M1_37_g N003_37_M1_37_s VDD_M1_37_b pmos l=1u w=4u
R_N003_37_M2_37_d N003_37 N003_37_M2_37_d 0.01
R_B_37_M2_37_g B_37 B_37_M2_37_g 0.01
R_N005_37_M2_37_s N005_37 N005_37_M2_37_s 0.01
R_VDD_M2_37_b VDD VDD_M2_37_b 0.01
M2_37 N003_37_M2_37_d B_37_M2_37_g N005_37_M2_37_s VDD_M2_37_b pmos l=1u w=4u
R_VDD_M3_37_d VDD VDD_M3_37_d 0.01
R_A_37_M3_37_g A_37 A_37_M3_37_g 0.01
R_N001_37_M3_37_s N001_37 N001_37_M3_37_s 0.01
R_VDD_M3_37_b VDD VDD_M3_37_b 0.01
M3_37 VDD_M3_37_d A_37_M3_37_g N001_37_M3_37_s VDD_M3_37_b pmos l=1u w=4u
R_N001_37_M4_37_d N001_37 N001_37_M4_37_d 0.01
R_C_37_M4_37_g C_37 C_37_M4_37_g 0.01
R_N005_37_M4_37_s N005_37 N005_37_M4_37_s 0.01
R_VDD_M4_37_b VDD VDD_M4_37_b 0.01
M4_37 N001_37_M4_37_d C_37_M4_37_g N005_37_M4_37_s VDD_M4_37_b pmos l=1u w=4u
R_VDD_M5_37_d VDD VDD_M5_37_d 0.01
R_B_37_M5_37_g B_37 B_37_M5_37_g 0.01
R_N001_37_M5_37_s N001_37 N001_37_M5_37_s 0.01
R_VDD_M5_37_b VDD VDD_M5_37_b 0.01
M5_37 VDD_M5_37_d B_37_M5_37_g N001_37_M5_37_s VDD_M5_37_b pmos l=1u w=4u
R_VDD_M6_37_d VDD VDD_M6_37_d 0.01
R_N005_37_M6_37_g N005_37 N005_37_M6_37_g 0.01
R_C_38_M6_37_s C_38 C_38_M6_37_s 0.01
R_VDD_M6_37_b VDD VDD_M6_37_b 0.01
M6_37 VDD_M6_37_d N005_37_M6_37_g C_38_M6_37_s VDD_M6_37_b pmos l=1u w=2u
R_VDD_M7_37_d VDD VDD_M7_37_d 0.01
R_A_37_M7_37_g A_37 A_37_M7_37_g 0.01
R_N002_37_M7_37_s N002_37 N002_37_M7_37_s 0.01
R_VDD_M7_37_b VDD VDD_M7_37_b 0.01
M7_37 VDD_M7_37_d A_37_M7_37_g N002_37_M7_37_s VDD_M7_37_b pmos l=1u w=4u
R_VDD_M8_37_d VDD VDD_M8_37_d 0.01
R_B_37_M8_37_g B_37 B_37_M8_37_g 0.01
R_N002_37_M8_37_s N002_37 N002_37_M8_37_s 0.01
R_VDD_M8_37_b VDD VDD_M8_37_b 0.01
M8_37 VDD_M8_37_d B_37_M8_37_g N002_37_M8_37_s VDD_M8_37_b pmos l=1u w=4u
R_VDD_M9_37_d VDD VDD_M9_37_d 0.01
R_C_37_M9_37_g C_37 C_37_M9_37_g 0.01
R_N002_37_M9_37_s N002_37 N002_37_M9_37_s 0.01
R_VDD_M9_37_b VDD VDD_M9_37_b 0.01
M9_37 VDD_M9_37_d C_37_M9_37_g N002_37_M9_37_s VDD_M9_37_b pmos l=1u w=4u
R_VDD_M10_37_d VDD VDD_M10_37_d 0.01
R_A_37_M10_37_g A_37 A_37_M10_37_g 0.01
R_N004_37_M10_37_s N004_37 N004_37_M10_37_s 0.01
R_VDD_M10_37_b VDD VDD_M10_37_b 0.01
M10_37 VDD_M10_37_d A_37_M10_37_g N004_37_M10_37_s VDD_M10_37_b pmos l=1u w=8u
R_N004_37_M11_37_d N004_37 N004_37_M11_37_d 0.01
R_B_37_M11_37_g B_37 B_37_M11_37_g 0.01
R_N006_37_M11_37_s N006_37 N006_37_M11_37_s 0.01
R_VDD_M11_37_b VDD VDD_M11_37_b 0.01
M11_37 N004_37_M11_37_d B_37_M11_37_g N006_37_M11_37_s VDD_M11_37_b pmos l=1u w=8u
R_N006_37_M12_37_d N006_37 N006_37_M12_37_d 0.01
R_C_37_M12_37_g C_37 C_37_M12_37_g 0.01
R_N007_37_M12_37_s N007_37 N007_37_M12_37_s 0.01
R_VDD_M12_37_b VDD VDD_M12_37_b 0.01
M12_37 N006_37_M12_37_d C_37_M12_37_g N007_37_M12_37_s VDD_M12_37_b pmos l=1u w=8u
R_N007_37_M13_37_d N007_37 N007_37_M13_37_d 0.01
R_C_37_M13_37_g C_37 C_37_M13_37_g 0.01
R_N008_37_M13_37_s N008_37 N008_37_M13_37_s 0.01
M13_37 N007_37_M13_37_d C_37_M13_37_g N008_37_M13_37_s 0 nmos l=1u w=8u
R_N008_37_M14_37_d N008_37 N008_37_M14_37_d 0.01
R_B_37_M14_37_g B_37 B_37_M14_37_g 0.01
R_N012_37_M14_37_s N012_37 N012_37_M14_37_s 0.01
M14_37 N008_37_M14_37_d B_37_M14_37_g N012_37_M14_37_s 0 nmos l=1u w=8u
R_N012_37_M15_37_d N012_37 N012_37_M15_37_d 0.01
R_A_37_M15_37_g A_37 A_37_M15_37_g 0.01
M15_37 N012_37_M15_37_d A_37_M15_37_g 0 0 nmos l=1u w=8u
R_N010_37_M16_37_d N010_37 N010_37_M16_37_d 0.01
R_C_37_M16_37_g C_37 C_37_M16_37_g 0.01
M16_37 N010_37_M16_37_d C_37_M16_37_g 0 0 nmos l=1u w=2u
R_N010_37_M17_37_d N010_37 N010_37_M17_37_d 0.01
R_B_37_M17_37_g B_37 B_37_M17_37_g 0.01
M17_37 N010_37_M17_37_d B_37_M17_37_g 0 0 nmos l=1u w=2u
R_N010_37_M18_37_d N010_37 N010_37_M18_37_d 0.01
R_A_37_M18_37_g A_37 A_37_M18_37_g 0.01
M18_37 N010_37_M18_37_d A_37_M18_37_g 0 0 nmos l=1u w=2u
R_N007_37_M19_37_d N007_37 N007_37_M19_37_d 0.01
R_N005_37_M19_37_g N005_37 N005_37_M19_37_g 0.01
R_N010_37_M19_37_s N010_37 N010_37_M19_37_s 0.01
M19_37 N007_37_M19_37_d N005_37_M19_37_g N010_37_M19_37_s 0 nmos l=1u w=2u
R_N009_37_M20_37_d N009_37 N009_37_M20_37_d 0.01
R_B_37_M20_37_g B_37 B_37_M20_37_g 0.01
M20_37 N009_37_M20_37_d B_37_M20_37_g 0 0 nmos l=1u w=2u
R_N009_37_M21_37_d N009_37 N009_37_M21_37_d 0.01
R_A_37_M21_37_g A_37 A_37_M21_37_g 0.01
M21_37 N009_37_M21_37_d A_37_M21_37_g 0 0 nmos l=1u w=2u
R_N011_37_M22_37_d N011_37 N011_37_M22_37_d 0.01
R_A_37_M22_37_g A_37 A_37_M22_37_g 0.01
M22_37 N011_37_M22_37_d A_37_M22_37_g 0 0 nmos l=1u w=2u
R_N005_37_M23_37_d N005_37 N005_37_M23_37_d 0.01
R_B_37_M23_37_g B_37 B_37_M23_37_g 0.01
R_N011_37_M23_37_s N011_37 N011_37_M23_37_s 0.01
M23_37 N005_37_M23_37_d B_37_M23_37_g N011_37_M23_37_s 0 nmos l=1u w=2u
R_N005_37_M24_37_d N005_37 N005_37_M24_37_d 0.01
R_C_37_M24_37_g C_37 C_37_M24_37_g 0.01
R_N009_37_M24_37_s N009_37 N009_37_M24_37_s 0.01
M24_37 N005_37_M24_37_d C_37_M24_37_g N009_37_M24_37_s 0 nmos l=1u w=2u
R_C_38_M25_37_d C_38 C_38_M25_37_d 0.01
R_N005_37_M25_37_g N005_37 N005_37_M25_37_g 0.01
M25_37 C_38_M25_37_d N005_37_M25_37_g 0 0 nmos l=1u w=1u
R_N002_37_M26_37_d N002_37 N002_37_M26_37_d 0.01
R_N005_37_M26_37_g N005_37 N005_37_M26_37_g 0.01
R_N007_37_M26_37_s N007_37 N007_37_M26_37_s 0.01
R_VDD_M26_37_b VDD VDD_M26_37_b 0.01
M26_37 N002_37_M26_37_d N005_37_M26_37_g N007_37_M26_37_s VDD_M26_37_b pmos l=1u w=4u
R_VDD_M27_37_d VDD VDD_M27_37_d 0.01
R_N007_37_M27_37_g N007_37 N007_37_M27_37_g 0.01
R_S_37_M27_37_s S_37 S_37_M27_37_s 0.01
R_VDD_M27_37_b VDD VDD_M27_37_b 0.01
M27_37 VDD_M27_37_d N007_37_M27_37_g S_37_M27_37_s VDD_M27_37_b pmos l=1u w=2u
R_S_37_M28_37_d S_37 S_37_M28_37_d 0.01
R_N007_37_M28_37_g N007_37 N007_37_M28_37_g 0.01
M28_37 S_37_M28_37_d N007_37_M28_37_g 0 0 nmos l=1u w=1u
C_S_37 S_37 0 1f
* --- Bit 38 ---
R_VDD_M1_38_d VDD VDD_M1_38_d 0.01
R_A_38_M1_38_g A_38 A_38_M1_38_g 0.01
R_N003_38_M1_38_s N003_38 N003_38_M1_38_s 0.01
R_VDD_M1_38_b VDD VDD_M1_38_b 0.01
M1_38 VDD_M1_38_d A_38_M1_38_g N003_38_M1_38_s VDD_M1_38_b pmos l=1u w=4u
R_N003_38_M2_38_d N003_38 N003_38_M2_38_d 0.01
R_B_38_M2_38_g B_38 B_38_M2_38_g 0.01
R_N005_38_M2_38_s N005_38 N005_38_M2_38_s 0.01
R_VDD_M2_38_b VDD VDD_M2_38_b 0.01
M2_38 N003_38_M2_38_d B_38_M2_38_g N005_38_M2_38_s VDD_M2_38_b pmos l=1u w=4u
R_VDD_M3_38_d VDD VDD_M3_38_d 0.01
R_A_38_M3_38_g A_38 A_38_M3_38_g 0.01
R_N001_38_M3_38_s N001_38 N001_38_M3_38_s 0.01
R_VDD_M3_38_b VDD VDD_M3_38_b 0.01
M3_38 VDD_M3_38_d A_38_M3_38_g N001_38_M3_38_s VDD_M3_38_b pmos l=1u w=4u
R_N001_38_M4_38_d N001_38 N001_38_M4_38_d 0.01
R_C_38_M4_38_g C_38 C_38_M4_38_g 0.01
R_N005_38_M4_38_s N005_38 N005_38_M4_38_s 0.01
R_VDD_M4_38_b VDD VDD_M4_38_b 0.01
M4_38 N001_38_M4_38_d C_38_M4_38_g N005_38_M4_38_s VDD_M4_38_b pmos l=1u w=4u
R_VDD_M5_38_d VDD VDD_M5_38_d 0.01
R_B_38_M5_38_g B_38 B_38_M5_38_g 0.01
R_N001_38_M5_38_s N001_38 N001_38_M5_38_s 0.01
R_VDD_M5_38_b VDD VDD_M5_38_b 0.01
M5_38 VDD_M5_38_d B_38_M5_38_g N001_38_M5_38_s VDD_M5_38_b pmos l=1u w=4u
R_VDD_M6_38_d VDD VDD_M6_38_d 0.01
R_N005_38_M6_38_g N005_38 N005_38_M6_38_g 0.01
R_C_39_M6_38_s C_39 C_39_M6_38_s 0.01
R_VDD_M6_38_b VDD VDD_M6_38_b 0.01
M6_38 VDD_M6_38_d N005_38_M6_38_g C_39_M6_38_s VDD_M6_38_b pmos l=1u w=2u
R_VDD_M7_38_d VDD VDD_M7_38_d 0.01
R_A_38_M7_38_g A_38 A_38_M7_38_g 0.01
R_N002_38_M7_38_s N002_38 N002_38_M7_38_s 0.01
R_VDD_M7_38_b VDD VDD_M7_38_b 0.01
M7_38 VDD_M7_38_d A_38_M7_38_g N002_38_M7_38_s VDD_M7_38_b pmos l=1u w=4u
R_VDD_M8_38_d VDD VDD_M8_38_d 0.01
R_B_38_M8_38_g B_38 B_38_M8_38_g 0.01
R_N002_38_M8_38_s N002_38 N002_38_M8_38_s 0.01
R_VDD_M8_38_b VDD VDD_M8_38_b 0.01
M8_38 VDD_M8_38_d B_38_M8_38_g N002_38_M8_38_s VDD_M8_38_b pmos l=1u w=4u
R_VDD_M9_38_d VDD VDD_M9_38_d 0.01
R_C_38_M9_38_g C_38 C_38_M9_38_g 0.01
R_N002_38_M9_38_s N002_38 N002_38_M9_38_s 0.01
R_VDD_M9_38_b VDD VDD_M9_38_b 0.01
M9_38 VDD_M9_38_d C_38_M9_38_g N002_38_M9_38_s VDD_M9_38_b pmos l=1u w=4u
R_VDD_M10_38_d VDD VDD_M10_38_d 0.01
R_A_38_M10_38_g A_38 A_38_M10_38_g 0.01
R_N004_38_M10_38_s N004_38 N004_38_M10_38_s 0.01
R_VDD_M10_38_b VDD VDD_M10_38_b 0.01
M10_38 VDD_M10_38_d A_38_M10_38_g N004_38_M10_38_s VDD_M10_38_b pmos l=1u w=8u
R_N004_38_M11_38_d N004_38 N004_38_M11_38_d 0.01
R_B_38_M11_38_g B_38 B_38_M11_38_g 0.01
R_N006_38_M11_38_s N006_38 N006_38_M11_38_s 0.01
R_VDD_M11_38_b VDD VDD_M11_38_b 0.01
M11_38 N004_38_M11_38_d B_38_M11_38_g N006_38_M11_38_s VDD_M11_38_b pmos l=1u w=8u
R_N006_38_M12_38_d N006_38 N006_38_M12_38_d 0.01
R_C_38_M12_38_g C_38 C_38_M12_38_g 0.01
R_N007_38_M12_38_s N007_38 N007_38_M12_38_s 0.01
R_VDD_M12_38_b VDD VDD_M12_38_b 0.01
M12_38 N006_38_M12_38_d C_38_M12_38_g N007_38_M12_38_s VDD_M12_38_b pmos l=1u w=8u
R_N007_38_M13_38_d N007_38 N007_38_M13_38_d 0.01
R_C_38_M13_38_g C_38 C_38_M13_38_g 0.01
R_N008_38_M13_38_s N008_38 N008_38_M13_38_s 0.01
M13_38 N007_38_M13_38_d C_38_M13_38_g N008_38_M13_38_s 0 nmos l=1u w=8u
R_N008_38_M14_38_d N008_38 N008_38_M14_38_d 0.01
R_B_38_M14_38_g B_38 B_38_M14_38_g 0.01
R_N012_38_M14_38_s N012_38 N012_38_M14_38_s 0.01
M14_38 N008_38_M14_38_d B_38_M14_38_g N012_38_M14_38_s 0 nmos l=1u w=8u
R_N012_38_M15_38_d N012_38 N012_38_M15_38_d 0.01
R_A_38_M15_38_g A_38 A_38_M15_38_g 0.01
M15_38 N012_38_M15_38_d A_38_M15_38_g 0 0 nmos l=1u w=8u
R_N010_38_M16_38_d N010_38 N010_38_M16_38_d 0.01
R_C_38_M16_38_g C_38 C_38_M16_38_g 0.01
M16_38 N010_38_M16_38_d C_38_M16_38_g 0 0 nmos l=1u w=2u
R_N010_38_M17_38_d N010_38 N010_38_M17_38_d 0.01
R_B_38_M17_38_g B_38 B_38_M17_38_g 0.01
M17_38 N010_38_M17_38_d B_38_M17_38_g 0 0 nmos l=1u w=2u
R_N010_38_M18_38_d N010_38 N010_38_M18_38_d 0.01
R_A_38_M18_38_g A_38 A_38_M18_38_g 0.01
M18_38 N010_38_M18_38_d A_38_M18_38_g 0 0 nmos l=1u w=2u
R_N007_38_M19_38_d N007_38 N007_38_M19_38_d 0.01
R_N005_38_M19_38_g N005_38 N005_38_M19_38_g 0.01
R_N010_38_M19_38_s N010_38 N010_38_M19_38_s 0.01
M19_38 N007_38_M19_38_d N005_38_M19_38_g N010_38_M19_38_s 0 nmos l=1u w=2u
R_N009_38_M20_38_d N009_38 N009_38_M20_38_d 0.01
R_B_38_M20_38_g B_38 B_38_M20_38_g 0.01
M20_38 N009_38_M20_38_d B_38_M20_38_g 0 0 nmos l=1u w=2u
R_N009_38_M21_38_d N009_38 N009_38_M21_38_d 0.01
R_A_38_M21_38_g A_38 A_38_M21_38_g 0.01
M21_38 N009_38_M21_38_d A_38_M21_38_g 0 0 nmos l=1u w=2u
R_N011_38_M22_38_d N011_38 N011_38_M22_38_d 0.01
R_A_38_M22_38_g A_38 A_38_M22_38_g 0.01
M22_38 N011_38_M22_38_d A_38_M22_38_g 0 0 nmos l=1u w=2u
R_N005_38_M23_38_d N005_38 N005_38_M23_38_d 0.01
R_B_38_M23_38_g B_38 B_38_M23_38_g 0.01
R_N011_38_M23_38_s N011_38 N011_38_M23_38_s 0.01
M23_38 N005_38_M23_38_d B_38_M23_38_g N011_38_M23_38_s 0 nmos l=1u w=2u
R_N005_38_M24_38_d N005_38 N005_38_M24_38_d 0.01
R_C_38_M24_38_g C_38 C_38_M24_38_g 0.01
R_N009_38_M24_38_s N009_38 N009_38_M24_38_s 0.01
M24_38 N005_38_M24_38_d C_38_M24_38_g N009_38_M24_38_s 0 nmos l=1u w=2u
R_C_39_M25_38_d C_39 C_39_M25_38_d 0.01
R_N005_38_M25_38_g N005_38 N005_38_M25_38_g 0.01
M25_38 C_39_M25_38_d N005_38_M25_38_g 0 0 nmos l=1u w=1u
R_N002_38_M26_38_d N002_38 N002_38_M26_38_d 0.01
R_N005_38_M26_38_g N005_38 N005_38_M26_38_g 0.01
R_N007_38_M26_38_s N007_38 N007_38_M26_38_s 0.01
R_VDD_M26_38_b VDD VDD_M26_38_b 0.01
M26_38 N002_38_M26_38_d N005_38_M26_38_g N007_38_M26_38_s VDD_M26_38_b pmos l=1u w=4u
R_VDD_M27_38_d VDD VDD_M27_38_d 0.01
R_N007_38_M27_38_g N007_38 N007_38_M27_38_g 0.01
R_S_38_M27_38_s S_38 S_38_M27_38_s 0.01
R_VDD_M27_38_b VDD VDD_M27_38_b 0.01
M27_38 VDD_M27_38_d N007_38_M27_38_g S_38_M27_38_s VDD_M27_38_b pmos l=1u w=2u
R_S_38_M28_38_d S_38 S_38_M28_38_d 0.01
R_N007_38_M28_38_g N007_38 N007_38_M28_38_g 0.01
M28_38 S_38_M28_38_d N007_38_M28_38_g 0 0 nmos l=1u w=1u
C_S_38 S_38 0 1f
* --- Bit 39 ---
R_VDD_M1_39_d VDD VDD_M1_39_d 0.01
R_A_39_M1_39_g A_39 A_39_M1_39_g 0.01
R_N003_39_M1_39_s N003_39 N003_39_M1_39_s 0.01
R_VDD_M1_39_b VDD VDD_M1_39_b 0.01
M1_39 VDD_M1_39_d A_39_M1_39_g N003_39_M1_39_s VDD_M1_39_b pmos l=1u w=4u
R_N003_39_M2_39_d N003_39 N003_39_M2_39_d 0.01
R_B_39_M2_39_g B_39 B_39_M2_39_g 0.01
R_N005_39_M2_39_s N005_39 N005_39_M2_39_s 0.01
R_VDD_M2_39_b VDD VDD_M2_39_b 0.01
M2_39 N003_39_M2_39_d B_39_M2_39_g N005_39_M2_39_s VDD_M2_39_b pmos l=1u w=4u
R_VDD_M3_39_d VDD VDD_M3_39_d 0.01
R_A_39_M3_39_g A_39 A_39_M3_39_g 0.01
R_N001_39_M3_39_s N001_39 N001_39_M3_39_s 0.01
R_VDD_M3_39_b VDD VDD_M3_39_b 0.01
M3_39 VDD_M3_39_d A_39_M3_39_g N001_39_M3_39_s VDD_M3_39_b pmos l=1u w=4u
R_N001_39_M4_39_d N001_39 N001_39_M4_39_d 0.01
R_C_39_M4_39_g C_39 C_39_M4_39_g 0.01
R_N005_39_M4_39_s N005_39 N005_39_M4_39_s 0.01
R_VDD_M4_39_b VDD VDD_M4_39_b 0.01
M4_39 N001_39_M4_39_d C_39_M4_39_g N005_39_M4_39_s VDD_M4_39_b pmos l=1u w=4u
R_VDD_M5_39_d VDD VDD_M5_39_d 0.01
R_B_39_M5_39_g B_39 B_39_M5_39_g 0.01
R_N001_39_M5_39_s N001_39 N001_39_M5_39_s 0.01
R_VDD_M5_39_b VDD VDD_M5_39_b 0.01
M5_39 VDD_M5_39_d B_39_M5_39_g N001_39_M5_39_s VDD_M5_39_b pmos l=1u w=4u
R_VDD_M6_39_d VDD VDD_M6_39_d 0.01
R_N005_39_M6_39_g N005_39 N005_39_M6_39_g 0.01
R_C_40_M6_39_s C_40 C_40_M6_39_s 0.01
R_VDD_M6_39_b VDD VDD_M6_39_b 0.01
M6_39 VDD_M6_39_d N005_39_M6_39_g C_40_M6_39_s VDD_M6_39_b pmos l=1u w=2u
R_VDD_M7_39_d VDD VDD_M7_39_d 0.01
R_A_39_M7_39_g A_39 A_39_M7_39_g 0.01
R_N002_39_M7_39_s N002_39 N002_39_M7_39_s 0.01
R_VDD_M7_39_b VDD VDD_M7_39_b 0.01
M7_39 VDD_M7_39_d A_39_M7_39_g N002_39_M7_39_s VDD_M7_39_b pmos l=1u w=4u
R_VDD_M8_39_d VDD VDD_M8_39_d 0.01
R_B_39_M8_39_g B_39 B_39_M8_39_g 0.01
R_N002_39_M8_39_s N002_39 N002_39_M8_39_s 0.01
R_VDD_M8_39_b VDD VDD_M8_39_b 0.01
M8_39 VDD_M8_39_d B_39_M8_39_g N002_39_M8_39_s VDD_M8_39_b pmos l=1u w=4u
R_VDD_M9_39_d VDD VDD_M9_39_d 0.01
R_C_39_M9_39_g C_39 C_39_M9_39_g 0.01
R_N002_39_M9_39_s N002_39 N002_39_M9_39_s 0.01
R_VDD_M9_39_b VDD VDD_M9_39_b 0.01
M9_39 VDD_M9_39_d C_39_M9_39_g N002_39_M9_39_s VDD_M9_39_b pmos l=1u w=4u
R_VDD_M10_39_d VDD VDD_M10_39_d 0.01
R_A_39_M10_39_g A_39 A_39_M10_39_g 0.01
R_N004_39_M10_39_s N004_39 N004_39_M10_39_s 0.01
R_VDD_M10_39_b VDD VDD_M10_39_b 0.01
M10_39 VDD_M10_39_d A_39_M10_39_g N004_39_M10_39_s VDD_M10_39_b pmos l=1u w=8u
R_N004_39_M11_39_d N004_39 N004_39_M11_39_d 0.01
R_B_39_M11_39_g B_39 B_39_M11_39_g 0.01
R_N006_39_M11_39_s N006_39 N006_39_M11_39_s 0.01
R_VDD_M11_39_b VDD VDD_M11_39_b 0.01
M11_39 N004_39_M11_39_d B_39_M11_39_g N006_39_M11_39_s VDD_M11_39_b pmos l=1u w=8u
R_N006_39_M12_39_d N006_39 N006_39_M12_39_d 0.01
R_C_39_M12_39_g C_39 C_39_M12_39_g 0.01
R_N007_39_M12_39_s N007_39 N007_39_M12_39_s 0.01
R_VDD_M12_39_b VDD VDD_M12_39_b 0.01
M12_39 N006_39_M12_39_d C_39_M12_39_g N007_39_M12_39_s VDD_M12_39_b pmos l=1u w=8u
R_N007_39_M13_39_d N007_39 N007_39_M13_39_d 0.01
R_C_39_M13_39_g C_39 C_39_M13_39_g 0.01
R_N008_39_M13_39_s N008_39 N008_39_M13_39_s 0.01
M13_39 N007_39_M13_39_d C_39_M13_39_g N008_39_M13_39_s 0 nmos l=1u w=8u
R_N008_39_M14_39_d N008_39 N008_39_M14_39_d 0.01
R_B_39_M14_39_g B_39 B_39_M14_39_g 0.01
R_N012_39_M14_39_s N012_39 N012_39_M14_39_s 0.01
M14_39 N008_39_M14_39_d B_39_M14_39_g N012_39_M14_39_s 0 nmos l=1u w=8u
R_N012_39_M15_39_d N012_39 N012_39_M15_39_d 0.01
R_A_39_M15_39_g A_39 A_39_M15_39_g 0.01
M15_39 N012_39_M15_39_d A_39_M15_39_g 0 0 nmos l=1u w=8u
R_N010_39_M16_39_d N010_39 N010_39_M16_39_d 0.01
R_C_39_M16_39_g C_39 C_39_M16_39_g 0.01
M16_39 N010_39_M16_39_d C_39_M16_39_g 0 0 nmos l=1u w=2u
R_N010_39_M17_39_d N010_39 N010_39_M17_39_d 0.01
R_B_39_M17_39_g B_39 B_39_M17_39_g 0.01
M17_39 N010_39_M17_39_d B_39_M17_39_g 0 0 nmos l=1u w=2u
R_N010_39_M18_39_d N010_39 N010_39_M18_39_d 0.01
R_A_39_M18_39_g A_39 A_39_M18_39_g 0.01
M18_39 N010_39_M18_39_d A_39_M18_39_g 0 0 nmos l=1u w=2u
R_N007_39_M19_39_d N007_39 N007_39_M19_39_d 0.01
R_N005_39_M19_39_g N005_39 N005_39_M19_39_g 0.01
R_N010_39_M19_39_s N010_39 N010_39_M19_39_s 0.01
M19_39 N007_39_M19_39_d N005_39_M19_39_g N010_39_M19_39_s 0 nmos l=1u w=2u
R_N009_39_M20_39_d N009_39 N009_39_M20_39_d 0.01
R_B_39_M20_39_g B_39 B_39_M20_39_g 0.01
M20_39 N009_39_M20_39_d B_39_M20_39_g 0 0 nmos l=1u w=2u
R_N009_39_M21_39_d N009_39 N009_39_M21_39_d 0.01
R_A_39_M21_39_g A_39 A_39_M21_39_g 0.01
M21_39 N009_39_M21_39_d A_39_M21_39_g 0 0 nmos l=1u w=2u
R_N011_39_M22_39_d N011_39 N011_39_M22_39_d 0.01
R_A_39_M22_39_g A_39 A_39_M22_39_g 0.01
M22_39 N011_39_M22_39_d A_39_M22_39_g 0 0 nmos l=1u w=2u
R_N005_39_M23_39_d N005_39 N005_39_M23_39_d 0.01
R_B_39_M23_39_g B_39 B_39_M23_39_g 0.01
R_N011_39_M23_39_s N011_39 N011_39_M23_39_s 0.01
M23_39 N005_39_M23_39_d B_39_M23_39_g N011_39_M23_39_s 0 nmos l=1u w=2u
R_N005_39_M24_39_d N005_39 N005_39_M24_39_d 0.01
R_C_39_M24_39_g C_39 C_39_M24_39_g 0.01
R_N009_39_M24_39_s N009_39 N009_39_M24_39_s 0.01
M24_39 N005_39_M24_39_d C_39_M24_39_g N009_39_M24_39_s 0 nmos l=1u w=2u
R_C_40_M25_39_d C_40 C_40_M25_39_d 0.01
R_N005_39_M25_39_g N005_39 N005_39_M25_39_g 0.01
M25_39 C_40_M25_39_d N005_39_M25_39_g 0 0 nmos l=1u w=1u
R_N002_39_M26_39_d N002_39 N002_39_M26_39_d 0.01
R_N005_39_M26_39_g N005_39 N005_39_M26_39_g 0.01
R_N007_39_M26_39_s N007_39 N007_39_M26_39_s 0.01
R_VDD_M26_39_b VDD VDD_M26_39_b 0.01
M26_39 N002_39_M26_39_d N005_39_M26_39_g N007_39_M26_39_s VDD_M26_39_b pmos l=1u w=4u
R_VDD_M27_39_d VDD VDD_M27_39_d 0.01
R_N007_39_M27_39_g N007_39 N007_39_M27_39_g 0.01
R_S_39_M27_39_s S_39 S_39_M27_39_s 0.01
R_VDD_M27_39_b VDD VDD_M27_39_b 0.01
M27_39 VDD_M27_39_d N007_39_M27_39_g S_39_M27_39_s VDD_M27_39_b pmos l=1u w=2u
R_S_39_M28_39_d S_39 S_39_M28_39_d 0.01
R_N007_39_M28_39_g N007_39 N007_39_M28_39_g 0.01
M28_39 S_39_M28_39_d N007_39_M28_39_g 0 0 nmos l=1u w=1u
C_S_39 S_39 0 1f
* --- Bit 40 ---
R_VDD_M1_40_d VDD VDD_M1_40_d 0.01
R_A_40_M1_40_g A_40 A_40_M1_40_g 0.01
R_N003_40_M1_40_s N003_40 N003_40_M1_40_s 0.01
R_VDD_M1_40_b VDD VDD_M1_40_b 0.01
M1_40 VDD_M1_40_d A_40_M1_40_g N003_40_M1_40_s VDD_M1_40_b pmos l=1u w=4u
R_N003_40_M2_40_d N003_40 N003_40_M2_40_d 0.01
R_B_40_M2_40_g B_40 B_40_M2_40_g 0.01
R_N005_40_M2_40_s N005_40 N005_40_M2_40_s 0.01
R_VDD_M2_40_b VDD VDD_M2_40_b 0.01
M2_40 N003_40_M2_40_d B_40_M2_40_g N005_40_M2_40_s VDD_M2_40_b pmos l=1u w=4u
R_VDD_M3_40_d VDD VDD_M3_40_d 0.01
R_A_40_M3_40_g A_40 A_40_M3_40_g 0.01
R_N001_40_M3_40_s N001_40 N001_40_M3_40_s 0.01
R_VDD_M3_40_b VDD VDD_M3_40_b 0.01
M3_40 VDD_M3_40_d A_40_M3_40_g N001_40_M3_40_s VDD_M3_40_b pmos l=1u w=4u
R_N001_40_M4_40_d N001_40 N001_40_M4_40_d 0.01
R_C_40_M4_40_g C_40 C_40_M4_40_g 0.01
R_N005_40_M4_40_s N005_40 N005_40_M4_40_s 0.01
R_VDD_M4_40_b VDD VDD_M4_40_b 0.01
M4_40 N001_40_M4_40_d C_40_M4_40_g N005_40_M4_40_s VDD_M4_40_b pmos l=1u w=4u
R_VDD_M5_40_d VDD VDD_M5_40_d 0.01
R_B_40_M5_40_g B_40 B_40_M5_40_g 0.01
R_N001_40_M5_40_s N001_40 N001_40_M5_40_s 0.01
R_VDD_M5_40_b VDD VDD_M5_40_b 0.01
M5_40 VDD_M5_40_d B_40_M5_40_g N001_40_M5_40_s VDD_M5_40_b pmos l=1u w=4u
R_VDD_M6_40_d VDD VDD_M6_40_d 0.01
R_N005_40_M6_40_g N005_40 N005_40_M6_40_g 0.01
R_C_41_M6_40_s C_41 C_41_M6_40_s 0.01
R_VDD_M6_40_b VDD VDD_M6_40_b 0.01
M6_40 VDD_M6_40_d N005_40_M6_40_g C_41_M6_40_s VDD_M6_40_b pmos l=1u w=2u
R_VDD_M7_40_d VDD VDD_M7_40_d 0.01
R_A_40_M7_40_g A_40 A_40_M7_40_g 0.01
R_N002_40_M7_40_s N002_40 N002_40_M7_40_s 0.01
R_VDD_M7_40_b VDD VDD_M7_40_b 0.01
M7_40 VDD_M7_40_d A_40_M7_40_g N002_40_M7_40_s VDD_M7_40_b pmos l=1u w=4u
R_VDD_M8_40_d VDD VDD_M8_40_d 0.01
R_B_40_M8_40_g B_40 B_40_M8_40_g 0.01
R_N002_40_M8_40_s N002_40 N002_40_M8_40_s 0.01
R_VDD_M8_40_b VDD VDD_M8_40_b 0.01
M8_40 VDD_M8_40_d B_40_M8_40_g N002_40_M8_40_s VDD_M8_40_b pmos l=1u w=4u
R_VDD_M9_40_d VDD VDD_M9_40_d 0.01
R_C_40_M9_40_g C_40 C_40_M9_40_g 0.01
R_N002_40_M9_40_s N002_40 N002_40_M9_40_s 0.01
R_VDD_M9_40_b VDD VDD_M9_40_b 0.01
M9_40 VDD_M9_40_d C_40_M9_40_g N002_40_M9_40_s VDD_M9_40_b pmos l=1u w=4u
R_VDD_M10_40_d VDD VDD_M10_40_d 0.01
R_A_40_M10_40_g A_40 A_40_M10_40_g 0.01
R_N004_40_M10_40_s N004_40 N004_40_M10_40_s 0.01
R_VDD_M10_40_b VDD VDD_M10_40_b 0.01
M10_40 VDD_M10_40_d A_40_M10_40_g N004_40_M10_40_s VDD_M10_40_b pmos l=1u w=8u
R_N004_40_M11_40_d N004_40 N004_40_M11_40_d 0.01
R_B_40_M11_40_g B_40 B_40_M11_40_g 0.01
R_N006_40_M11_40_s N006_40 N006_40_M11_40_s 0.01
R_VDD_M11_40_b VDD VDD_M11_40_b 0.01
M11_40 N004_40_M11_40_d B_40_M11_40_g N006_40_M11_40_s VDD_M11_40_b pmos l=1u w=8u
R_N006_40_M12_40_d N006_40 N006_40_M12_40_d 0.01
R_C_40_M12_40_g C_40 C_40_M12_40_g 0.01
R_N007_40_M12_40_s N007_40 N007_40_M12_40_s 0.01
R_VDD_M12_40_b VDD VDD_M12_40_b 0.01
M12_40 N006_40_M12_40_d C_40_M12_40_g N007_40_M12_40_s VDD_M12_40_b pmos l=1u w=8u
R_N007_40_M13_40_d N007_40 N007_40_M13_40_d 0.01
R_C_40_M13_40_g C_40 C_40_M13_40_g 0.01
R_N008_40_M13_40_s N008_40 N008_40_M13_40_s 0.01
M13_40 N007_40_M13_40_d C_40_M13_40_g N008_40_M13_40_s 0 nmos l=1u w=8u
R_N008_40_M14_40_d N008_40 N008_40_M14_40_d 0.01
R_B_40_M14_40_g B_40 B_40_M14_40_g 0.01
R_N012_40_M14_40_s N012_40 N012_40_M14_40_s 0.01
M14_40 N008_40_M14_40_d B_40_M14_40_g N012_40_M14_40_s 0 nmos l=1u w=8u
R_N012_40_M15_40_d N012_40 N012_40_M15_40_d 0.01
R_A_40_M15_40_g A_40 A_40_M15_40_g 0.01
M15_40 N012_40_M15_40_d A_40_M15_40_g 0 0 nmos l=1u w=8u
R_N010_40_M16_40_d N010_40 N010_40_M16_40_d 0.01
R_C_40_M16_40_g C_40 C_40_M16_40_g 0.01
M16_40 N010_40_M16_40_d C_40_M16_40_g 0 0 nmos l=1u w=2u
R_N010_40_M17_40_d N010_40 N010_40_M17_40_d 0.01
R_B_40_M17_40_g B_40 B_40_M17_40_g 0.01
M17_40 N010_40_M17_40_d B_40_M17_40_g 0 0 nmos l=1u w=2u
R_N010_40_M18_40_d N010_40 N010_40_M18_40_d 0.01
R_A_40_M18_40_g A_40 A_40_M18_40_g 0.01
M18_40 N010_40_M18_40_d A_40_M18_40_g 0 0 nmos l=1u w=2u
R_N007_40_M19_40_d N007_40 N007_40_M19_40_d 0.01
R_N005_40_M19_40_g N005_40 N005_40_M19_40_g 0.01
R_N010_40_M19_40_s N010_40 N010_40_M19_40_s 0.01
M19_40 N007_40_M19_40_d N005_40_M19_40_g N010_40_M19_40_s 0 nmos l=1u w=2u
R_N009_40_M20_40_d N009_40 N009_40_M20_40_d 0.01
R_B_40_M20_40_g B_40 B_40_M20_40_g 0.01
M20_40 N009_40_M20_40_d B_40_M20_40_g 0 0 nmos l=1u w=2u
R_N009_40_M21_40_d N009_40 N009_40_M21_40_d 0.01
R_A_40_M21_40_g A_40 A_40_M21_40_g 0.01
M21_40 N009_40_M21_40_d A_40_M21_40_g 0 0 nmos l=1u w=2u
R_N011_40_M22_40_d N011_40 N011_40_M22_40_d 0.01
R_A_40_M22_40_g A_40 A_40_M22_40_g 0.01
M22_40 N011_40_M22_40_d A_40_M22_40_g 0 0 nmos l=1u w=2u
R_N005_40_M23_40_d N005_40 N005_40_M23_40_d 0.01
R_B_40_M23_40_g B_40 B_40_M23_40_g 0.01
R_N011_40_M23_40_s N011_40 N011_40_M23_40_s 0.01
M23_40 N005_40_M23_40_d B_40_M23_40_g N011_40_M23_40_s 0 nmos l=1u w=2u
R_N005_40_M24_40_d N005_40 N005_40_M24_40_d 0.01
R_C_40_M24_40_g C_40 C_40_M24_40_g 0.01
R_N009_40_M24_40_s N009_40 N009_40_M24_40_s 0.01
M24_40 N005_40_M24_40_d C_40_M24_40_g N009_40_M24_40_s 0 nmos l=1u w=2u
R_C_41_M25_40_d C_41 C_41_M25_40_d 0.01
R_N005_40_M25_40_g N005_40 N005_40_M25_40_g 0.01
M25_40 C_41_M25_40_d N005_40_M25_40_g 0 0 nmos l=1u w=1u
R_N002_40_M26_40_d N002_40 N002_40_M26_40_d 0.01
R_N005_40_M26_40_g N005_40 N005_40_M26_40_g 0.01
R_N007_40_M26_40_s N007_40 N007_40_M26_40_s 0.01
R_VDD_M26_40_b VDD VDD_M26_40_b 0.01
M26_40 N002_40_M26_40_d N005_40_M26_40_g N007_40_M26_40_s VDD_M26_40_b pmos l=1u w=4u
R_VDD_M27_40_d VDD VDD_M27_40_d 0.01
R_N007_40_M27_40_g N007_40 N007_40_M27_40_g 0.01
R_S_40_M27_40_s S_40 S_40_M27_40_s 0.01
R_VDD_M27_40_b VDD VDD_M27_40_b 0.01
M27_40 VDD_M27_40_d N007_40_M27_40_g S_40_M27_40_s VDD_M27_40_b pmos l=1u w=2u
R_S_40_M28_40_d S_40 S_40_M28_40_d 0.01
R_N007_40_M28_40_g N007_40 N007_40_M28_40_g 0.01
M28_40 S_40_M28_40_d N007_40_M28_40_g 0 0 nmos l=1u w=1u
C_S_40 S_40 0 1f
* --- Bit 41 ---
R_VDD_M1_41_d VDD VDD_M1_41_d 0.01
R_A_41_M1_41_g A_41 A_41_M1_41_g 0.01
R_N003_41_M1_41_s N003_41 N003_41_M1_41_s 0.01
R_VDD_M1_41_b VDD VDD_M1_41_b 0.01
M1_41 VDD_M1_41_d A_41_M1_41_g N003_41_M1_41_s VDD_M1_41_b pmos l=1u w=4u
R_N003_41_M2_41_d N003_41 N003_41_M2_41_d 0.01
R_B_41_M2_41_g B_41 B_41_M2_41_g 0.01
R_N005_41_M2_41_s N005_41 N005_41_M2_41_s 0.01
R_VDD_M2_41_b VDD VDD_M2_41_b 0.01
M2_41 N003_41_M2_41_d B_41_M2_41_g N005_41_M2_41_s VDD_M2_41_b pmos l=1u w=4u
R_VDD_M3_41_d VDD VDD_M3_41_d 0.01
R_A_41_M3_41_g A_41 A_41_M3_41_g 0.01
R_N001_41_M3_41_s N001_41 N001_41_M3_41_s 0.01
R_VDD_M3_41_b VDD VDD_M3_41_b 0.01
M3_41 VDD_M3_41_d A_41_M3_41_g N001_41_M3_41_s VDD_M3_41_b pmos l=1u w=4u
R_N001_41_M4_41_d N001_41 N001_41_M4_41_d 0.01
R_C_41_M4_41_g C_41 C_41_M4_41_g 0.01
R_N005_41_M4_41_s N005_41 N005_41_M4_41_s 0.01
R_VDD_M4_41_b VDD VDD_M4_41_b 0.01
M4_41 N001_41_M4_41_d C_41_M4_41_g N005_41_M4_41_s VDD_M4_41_b pmos l=1u w=4u
R_VDD_M5_41_d VDD VDD_M5_41_d 0.01
R_B_41_M5_41_g B_41 B_41_M5_41_g 0.01
R_N001_41_M5_41_s N001_41 N001_41_M5_41_s 0.01
R_VDD_M5_41_b VDD VDD_M5_41_b 0.01
M5_41 VDD_M5_41_d B_41_M5_41_g N001_41_M5_41_s VDD_M5_41_b pmos l=1u w=4u
R_VDD_M6_41_d VDD VDD_M6_41_d 0.01
R_N005_41_M6_41_g N005_41 N005_41_M6_41_g 0.01
R_C_42_M6_41_s C_42 C_42_M6_41_s 0.01
R_VDD_M6_41_b VDD VDD_M6_41_b 0.01
M6_41 VDD_M6_41_d N005_41_M6_41_g C_42_M6_41_s VDD_M6_41_b pmos l=1u w=2u
R_VDD_M7_41_d VDD VDD_M7_41_d 0.01
R_A_41_M7_41_g A_41 A_41_M7_41_g 0.01
R_N002_41_M7_41_s N002_41 N002_41_M7_41_s 0.01
R_VDD_M7_41_b VDD VDD_M7_41_b 0.01
M7_41 VDD_M7_41_d A_41_M7_41_g N002_41_M7_41_s VDD_M7_41_b pmos l=1u w=4u
R_VDD_M8_41_d VDD VDD_M8_41_d 0.01
R_B_41_M8_41_g B_41 B_41_M8_41_g 0.01
R_N002_41_M8_41_s N002_41 N002_41_M8_41_s 0.01
R_VDD_M8_41_b VDD VDD_M8_41_b 0.01
M8_41 VDD_M8_41_d B_41_M8_41_g N002_41_M8_41_s VDD_M8_41_b pmos l=1u w=4u
R_VDD_M9_41_d VDD VDD_M9_41_d 0.01
R_C_41_M9_41_g C_41 C_41_M9_41_g 0.01
R_N002_41_M9_41_s N002_41 N002_41_M9_41_s 0.01
R_VDD_M9_41_b VDD VDD_M9_41_b 0.01
M9_41 VDD_M9_41_d C_41_M9_41_g N002_41_M9_41_s VDD_M9_41_b pmos l=1u w=4u
R_VDD_M10_41_d VDD VDD_M10_41_d 0.01
R_A_41_M10_41_g A_41 A_41_M10_41_g 0.01
R_N004_41_M10_41_s N004_41 N004_41_M10_41_s 0.01
R_VDD_M10_41_b VDD VDD_M10_41_b 0.01
M10_41 VDD_M10_41_d A_41_M10_41_g N004_41_M10_41_s VDD_M10_41_b pmos l=1u w=8u
R_N004_41_M11_41_d N004_41 N004_41_M11_41_d 0.01
R_B_41_M11_41_g B_41 B_41_M11_41_g 0.01
R_N006_41_M11_41_s N006_41 N006_41_M11_41_s 0.01
R_VDD_M11_41_b VDD VDD_M11_41_b 0.01
M11_41 N004_41_M11_41_d B_41_M11_41_g N006_41_M11_41_s VDD_M11_41_b pmos l=1u w=8u
R_N006_41_M12_41_d N006_41 N006_41_M12_41_d 0.01
R_C_41_M12_41_g C_41 C_41_M12_41_g 0.01
R_N007_41_M12_41_s N007_41 N007_41_M12_41_s 0.01
R_VDD_M12_41_b VDD VDD_M12_41_b 0.01
M12_41 N006_41_M12_41_d C_41_M12_41_g N007_41_M12_41_s VDD_M12_41_b pmos l=1u w=8u
R_N007_41_M13_41_d N007_41 N007_41_M13_41_d 0.01
R_C_41_M13_41_g C_41 C_41_M13_41_g 0.01
R_N008_41_M13_41_s N008_41 N008_41_M13_41_s 0.01
M13_41 N007_41_M13_41_d C_41_M13_41_g N008_41_M13_41_s 0 nmos l=1u w=8u
R_N008_41_M14_41_d N008_41 N008_41_M14_41_d 0.01
R_B_41_M14_41_g B_41 B_41_M14_41_g 0.01
R_N012_41_M14_41_s N012_41 N012_41_M14_41_s 0.01
M14_41 N008_41_M14_41_d B_41_M14_41_g N012_41_M14_41_s 0 nmos l=1u w=8u
R_N012_41_M15_41_d N012_41 N012_41_M15_41_d 0.01
R_A_41_M15_41_g A_41 A_41_M15_41_g 0.01
M15_41 N012_41_M15_41_d A_41_M15_41_g 0 0 nmos l=1u w=8u
R_N010_41_M16_41_d N010_41 N010_41_M16_41_d 0.01
R_C_41_M16_41_g C_41 C_41_M16_41_g 0.01
M16_41 N010_41_M16_41_d C_41_M16_41_g 0 0 nmos l=1u w=2u
R_N010_41_M17_41_d N010_41 N010_41_M17_41_d 0.01
R_B_41_M17_41_g B_41 B_41_M17_41_g 0.01
M17_41 N010_41_M17_41_d B_41_M17_41_g 0 0 nmos l=1u w=2u
R_N010_41_M18_41_d N010_41 N010_41_M18_41_d 0.01
R_A_41_M18_41_g A_41 A_41_M18_41_g 0.01
M18_41 N010_41_M18_41_d A_41_M18_41_g 0 0 nmos l=1u w=2u
R_N007_41_M19_41_d N007_41 N007_41_M19_41_d 0.01
R_N005_41_M19_41_g N005_41 N005_41_M19_41_g 0.01
R_N010_41_M19_41_s N010_41 N010_41_M19_41_s 0.01
M19_41 N007_41_M19_41_d N005_41_M19_41_g N010_41_M19_41_s 0 nmos l=1u w=2u
R_N009_41_M20_41_d N009_41 N009_41_M20_41_d 0.01
R_B_41_M20_41_g B_41 B_41_M20_41_g 0.01
M20_41 N009_41_M20_41_d B_41_M20_41_g 0 0 nmos l=1u w=2u
R_N009_41_M21_41_d N009_41 N009_41_M21_41_d 0.01
R_A_41_M21_41_g A_41 A_41_M21_41_g 0.01
M21_41 N009_41_M21_41_d A_41_M21_41_g 0 0 nmos l=1u w=2u
R_N011_41_M22_41_d N011_41 N011_41_M22_41_d 0.01
R_A_41_M22_41_g A_41 A_41_M22_41_g 0.01
M22_41 N011_41_M22_41_d A_41_M22_41_g 0 0 nmos l=1u w=2u
R_N005_41_M23_41_d N005_41 N005_41_M23_41_d 0.01
R_B_41_M23_41_g B_41 B_41_M23_41_g 0.01
R_N011_41_M23_41_s N011_41 N011_41_M23_41_s 0.01
M23_41 N005_41_M23_41_d B_41_M23_41_g N011_41_M23_41_s 0 nmos l=1u w=2u
R_N005_41_M24_41_d N005_41 N005_41_M24_41_d 0.01
R_C_41_M24_41_g C_41 C_41_M24_41_g 0.01
R_N009_41_M24_41_s N009_41 N009_41_M24_41_s 0.01
M24_41 N005_41_M24_41_d C_41_M24_41_g N009_41_M24_41_s 0 nmos l=1u w=2u
R_C_42_M25_41_d C_42 C_42_M25_41_d 0.01
R_N005_41_M25_41_g N005_41 N005_41_M25_41_g 0.01
M25_41 C_42_M25_41_d N005_41_M25_41_g 0 0 nmos l=1u w=1u
R_N002_41_M26_41_d N002_41 N002_41_M26_41_d 0.01
R_N005_41_M26_41_g N005_41 N005_41_M26_41_g 0.01
R_N007_41_M26_41_s N007_41 N007_41_M26_41_s 0.01
R_VDD_M26_41_b VDD VDD_M26_41_b 0.01
M26_41 N002_41_M26_41_d N005_41_M26_41_g N007_41_M26_41_s VDD_M26_41_b pmos l=1u w=4u
R_VDD_M27_41_d VDD VDD_M27_41_d 0.01
R_N007_41_M27_41_g N007_41 N007_41_M27_41_g 0.01
R_S_41_M27_41_s S_41 S_41_M27_41_s 0.01
R_VDD_M27_41_b VDD VDD_M27_41_b 0.01
M27_41 VDD_M27_41_d N007_41_M27_41_g S_41_M27_41_s VDD_M27_41_b pmos l=1u w=2u
R_S_41_M28_41_d S_41 S_41_M28_41_d 0.01
R_N007_41_M28_41_g N007_41 N007_41_M28_41_g 0.01
M28_41 S_41_M28_41_d N007_41_M28_41_g 0 0 nmos l=1u w=1u
C_S_41 S_41 0 1f
* --- Bit 42 ---
R_VDD_M1_42_d VDD VDD_M1_42_d 0.01
R_A_42_M1_42_g A_42 A_42_M1_42_g 0.01
R_N003_42_M1_42_s N003_42 N003_42_M1_42_s 0.01
R_VDD_M1_42_b VDD VDD_M1_42_b 0.01
M1_42 VDD_M1_42_d A_42_M1_42_g N003_42_M1_42_s VDD_M1_42_b pmos l=1u w=4u
R_N003_42_M2_42_d N003_42 N003_42_M2_42_d 0.01
R_B_42_M2_42_g B_42 B_42_M2_42_g 0.01
R_N005_42_M2_42_s N005_42 N005_42_M2_42_s 0.01
R_VDD_M2_42_b VDD VDD_M2_42_b 0.01
M2_42 N003_42_M2_42_d B_42_M2_42_g N005_42_M2_42_s VDD_M2_42_b pmos l=1u w=4u
R_VDD_M3_42_d VDD VDD_M3_42_d 0.01
R_A_42_M3_42_g A_42 A_42_M3_42_g 0.01
R_N001_42_M3_42_s N001_42 N001_42_M3_42_s 0.01
R_VDD_M3_42_b VDD VDD_M3_42_b 0.01
M3_42 VDD_M3_42_d A_42_M3_42_g N001_42_M3_42_s VDD_M3_42_b pmos l=1u w=4u
R_N001_42_M4_42_d N001_42 N001_42_M4_42_d 0.01
R_C_42_M4_42_g C_42 C_42_M4_42_g 0.01
R_N005_42_M4_42_s N005_42 N005_42_M4_42_s 0.01
R_VDD_M4_42_b VDD VDD_M4_42_b 0.01
M4_42 N001_42_M4_42_d C_42_M4_42_g N005_42_M4_42_s VDD_M4_42_b pmos l=1u w=4u
R_VDD_M5_42_d VDD VDD_M5_42_d 0.01
R_B_42_M5_42_g B_42 B_42_M5_42_g 0.01
R_N001_42_M5_42_s N001_42 N001_42_M5_42_s 0.01
R_VDD_M5_42_b VDD VDD_M5_42_b 0.01
M5_42 VDD_M5_42_d B_42_M5_42_g N001_42_M5_42_s VDD_M5_42_b pmos l=1u w=4u
R_VDD_M6_42_d VDD VDD_M6_42_d 0.01
R_N005_42_M6_42_g N005_42 N005_42_M6_42_g 0.01
R_C_43_M6_42_s C_43 C_43_M6_42_s 0.01
R_VDD_M6_42_b VDD VDD_M6_42_b 0.01
M6_42 VDD_M6_42_d N005_42_M6_42_g C_43_M6_42_s VDD_M6_42_b pmos l=1u w=2u
R_VDD_M7_42_d VDD VDD_M7_42_d 0.01
R_A_42_M7_42_g A_42 A_42_M7_42_g 0.01
R_N002_42_M7_42_s N002_42 N002_42_M7_42_s 0.01
R_VDD_M7_42_b VDD VDD_M7_42_b 0.01
M7_42 VDD_M7_42_d A_42_M7_42_g N002_42_M7_42_s VDD_M7_42_b pmos l=1u w=4u
R_VDD_M8_42_d VDD VDD_M8_42_d 0.01
R_B_42_M8_42_g B_42 B_42_M8_42_g 0.01
R_N002_42_M8_42_s N002_42 N002_42_M8_42_s 0.01
R_VDD_M8_42_b VDD VDD_M8_42_b 0.01
M8_42 VDD_M8_42_d B_42_M8_42_g N002_42_M8_42_s VDD_M8_42_b pmos l=1u w=4u
R_VDD_M9_42_d VDD VDD_M9_42_d 0.01
R_C_42_M9_42_g C_42 C_42_M9_42_g 0.01
R_N002_42_M9_42_s N002_42 N002_42_M9_42_s 0.01
R_VDD_M9_42_b VDD VDD_M9_42_b 0.01
M9_42 VDD_M9_42_d C_42_M9_42_g N002_42_M9_42_s VDD_M9_42_b pmos l=1u w=4u
R_VDD_M10_42_d VDD VDD_M10_42_d 0.01
R_A_42_M10_42_g A_42 A_42_M10_42_g 0.01
R_N004_42_M10_42_s N004_42 N004_42_M10_42_s 0.01
R_VDD_M10_42_b VDD VDD_M10_42_b 0.01
M10_42 VDD_M10_42_d A_42_M10_42_g N004_42_M10_42_s VDD_M10_42_b pmos l=1u w=8u
R_N004_42_M11_42_d N004_42 N004_42_M11_42_d 0.01
R_B_42_M11_42_g B_42 B_42_M11_42_g 0.01
R_N006_42_M11_42_s N006_42 N006_42_M11_42_s 0.01
R_VDD_M11_42_b VDD VDD_M11_42_b 0.01
M11_42 N004_42_M11_42_d B_42_M11_42_g N006_42_M11_42_s VDD_M11_42_b pmos l=1u w=8u
R_N006_42_M12_42_d N006_42 N006_42_M12_42_d 0.01
R_C_42_M12_42_g C_42 C_42_M12_42_g 0.01
R_N007_42_M12_42_s N007_42 N007_42_M12_42_s 0.01
R_VDD_M12_42_b VDD VDD_M12_42_b 0.01
M12_42 N006_42_M12_42_d C_42_M12_42_g N007_42_M12_42_s VDD_M12_42_b pmos l=1u w=8u
R_N007_42_M13_42_d N007_42 N007_42_M13_42_d 0.01
R_C_42_M13_42_g C_42 C_42_M13_42_g 0.01
R_N008_42_M13_42_s N008_42 N008_42_M13_42_s 0.01
M13_42 N007_42_M13_42_d C_42_M13_42_g N008_42_M13_42_s 0 nmos l=1u w=8u
R_N008_42_M14_42_d N008_42 N008_42_M14_42_d 0.01
R_B_42_M14_42_g B_42 B_42_M14_42_g 0.01
R_N012_42_M14_42_s N012_42 N012_42_M14_42_s 0.01
M14_42 N008_42_M14_42_d B_42_M14_42_g N012_42_M14_42_s 0 nmos l=1u w=8u
R_N012_42_M15_42_d N012_42 N012_42_M15_42_d 0.01
R_A_42_M15_42_g A_42 A_42_M15_42_g 0.01
M15_42 N012_42_M15_42_d A_42_M15_42_g 0 0 nmos l=1u w=8u
R_N010_42_M16_42_d N010_42 N010_42_M16_42_d 0.01
R_C_42_M16_42_g C_42 C_42_M16_42_g 0.01
M16_42 N010_42_M16_42_d C_42_M16_42_g 0 0 nmos l=1u w=2u
R_N010_42_M17_42_d N010_42 N010_42_M17_42_d 0.01
R_B_42_M17_42_g B_42 B_42_M17_42_g 0.01
M17_42 N010_42_M17_42_d B_42_M17_42_g 0 0 nmos l=1u w=2u
R_N010_42_M18_42_d N010_42 N010_42_M18_42_d 0.01
R_A_42_M18_42_g A_42 A_42_M18_42_g 0.01
M18_42 N010_42_M18_42_d A_42_M18_42_g 0 0 nmos l=1u w=2u
R_N007_42_M19_42_d N007_42 N007_42_M19_42_d 0.01
R_N005_42_M19_42_g N005_42 N005_42_M19_42_g 0.01
R_N010_42_M19_42_s N010_42 N010_42_M19_42_s 0.01
M19_42 N007_42_M19_42_d N005_42_M19_42_g N010_42_M19_42_s 0 nmos l=1u w=2u
R_N009_42_M20_42_d N009_42 N009_42_M20_42_d 0.01
R_B_42_M20_42_g B_42 B_42_M20_42_g 0.01
M20_42 N009_42_M20_42_d B_42_M20_42_g 0 0 nmos l=1u w=2u
R_N009_42_M21_42_d N009_42 N009_42_M21_42_d 0.01
R_A_42_M21_42_g A_42 A_42_M21_42_g 0.01
M21_42 N009_42_M21_42_d A_42_M21_42_g 0 0 nmos l=1u w=2u
R_N011_42_M22_42_d N011_42 N011_42_M22_42_d 0.01
R_A_42_M22_42_g A_42 A_42_M22_42_g 0.01
M22_42 N011_42_M22_42_d A_42_M22_42_g 0 0 nmos l=1u w=2u
R_N005_42_M23_42_d N005_42 N005_42_M23_42_d 0.01
R_B_42_M23_42_g B_42 B_42_M23_42_g 0.01
R_N011_42_M23_42_s N011_42 N011_42_M23_42_s 0.01
M23_42 N005_42_M23_42_d B_42_M23_42_g N011_42_M23_42_s 0 nmos l=1u w=2u
R_N005_42_M24_42_d N005_42 N005_42_M24_42_d 0.01
R_C_42_M24_42_g C_42 C_42_M24_42_g 0.01
R_N009_42_M24_42_s N009_42 N009_42_M24_42_s 0.01
M24_42 N005_42_M24_42_d C_42_M24_42_g N009_42_M24_42_s 0 nmos l=1u w=2u
R_C_43_M25_42_d C_43 C_43_M25_42_d 0.01
R_N005_42_M25_42_g N005_42 N005_42_M25_42_g 0.01
M25_42 C_43_M25_42_d N005_42_M25_42_g 0 0 nmos l=1u w=1u
R_N002_42_M26_42_d N002_42 N002_42_M26_42_d 0.01
R_N005_42_M26_42_g N005_42 N005_42_M26_42_g 0.01
R_N007_42_M26_42_s N007_42 N007_42_M26_42_s 0.01
R_VDD_M26_42_b VDD VDD_M26_42_b 0.01
M26_42 N002_42_M26_42_d N005_42_M26_42_g N007_42_M26_42_s VDD_M26_42_b pmos l=1u w=4u
R_VDD_M27_42_d VDD VDD_M27_42_d 0.01
R_N007_42_M27_42_g N007_42 N007_42_M27_42_g 0.01
R_S_42_M27_42_s S_42 S_42_M27_42_s 0.01
R_VDD_M27_42_b VDD VDD_M27_42_b 0.01
M27_42 VDD_M27_42_d N007_42_M27_42_g S_42_M27_42_s VDD_M27_42_b pmos l=1u w=2u
R_S_42_M28_42_d S_42 S_42_M28_42_d 0.01
R_N007_42_M28_42_g N007_42 N007_42_M28_42_g 0.01
M28_42 S_42_M28_42_d N007_42_M28_42_g 0 0 nmos l=1u w=1u
C_S_42 S_42 0 1f
* --- Bit 43 ---
R_VDD_M1_43_d VDD VDD_M1_43_d 0.01
R_A_43_M1_43_g A_43 A_43_M1_43_g 0.01
R_N003_43_M1_43_s N003_43 N003_43_M1_43_s 0.01
R_VDD_M1_43_b VDD VDD_M1_43_b 0.01
M1_43 VDD_M1_43_d A_43_M1_43_g N003_43_M1_43_s VDD_M1_43_b pmos l=1u w=4u
R_N003_43_M2_43_d N003_43 N003_43_M2_43_d 0.01
R_B_43_M2_43_g B_43 B_43_M2_43_g 0.01
R_N005_43_M2_43_s N005_43 N005_43_M2_43_s 0.01
R_VDD_M2_43_b VDD VDD_M2_43_b 0.01
M2_43 N003_43_M2_43_d B_43_M2_43_g N005_43_M2_43_s VDD_M2_43_b pmos l=1u w=4u
R_VDD_M3_43_d VDD VDD_M3_43_d 0.01
R_A_43_M3_43_g A_43 A_43_M3_43_g 0.01
R_N001_43_M3_43_s N001_43 N001_43_M3_43_s 0.01
R_VDD_M3_43_b VDD VDD_M3_43_b 0.01
M3_43 VDD_M3_43_d A_43_M3_43_g N001_43_M3_43_s VDD_M3_43_b pmos l=1u w=4u
R_N001_43_M4_43_d N001_43 N001_43_M4_43_d 0.01
R_C_43_M4_43_g C_43 C_43_M4_43_g 0.01
R_N005_43_M4_43_s N005_43 N005_43_M4_43_s 0.01
R_VDD_M4_43_b VDD VDD_M4_43_b 0.01
M4_43 N001_43_M4_43_d C_43_M4_43_g N005_43_M4_43_s VDD_M4_43_b pmos l=1u w=4u
R_VDD_M5_43_d VDD VDD_M5_43_d 0.01
R_B_43_M5_43_g B_43 B_43_M5_43_g 0.01
R_N001_43_M5_43_s N001_43 N001_43_M5_43_s 0.01
R_VDD_M5_43_b VDD VDD_M5_43_b 0.01
M5_43 VDD_M5_43_d B_43_M5_43_g N001_43_M5_43_s VDD_M5_43_b pmos l=1u w=4u
R_VDD_M6_43_d VDD VDD_M6_43_d 0.01
R_N005_43_M6_43_g N005_43 N005_43_M6_43_g 0.01
R_C_44_M6_43_s C_44 C_44_M6_43_s 0.01
R_VDD_M6_43_b VDD VDD_M6_43_b 0.01
M6_43 VDD_M6_43_d N005_43_M6_43_g C_44_M6_43_s VDD_M6_43_b pmos l=1u w=2u
R_VDD_M7_43_d VDD VDD_M7_43_d 0.01
R_A_43_M7_43_g A_43 A_43_M7_43_g 0.01
R_N002_43_M7_43_s N002_43 N002_43_M7_43_s 0.01
R_VDD_M7_43_b VDD VDD_M7_43_b 0.01
M7_43 VDD_M7_43_d A_43_M7_43_g N002_43_M7_43_s VDD_M7_43_b pmos l=1u w=4u
R_VDD_M8_43_d VDD VDD_M8_43_d 0.01
R_B_43_M8_43_g B_43 B_43_M8_43_g 0.01
R_N002_43_M8_43_s N002_43 N002_43_M8_43_s 0.01
R_VDD_M8_43_b VDD VDD_M8_43_b 0.01
M8_43 VDD_M8_43_d B_43_M8_43_g N002_43_M8_43_s VDD_M8_43_b pmos l=1u w=4u
R_VDD_M9_43_d VDD VDD_M9_43_d 0.01
R_C_43_M9_43_g C_43 C_43_M9_43_g 0.01
R_N002_43_M9_43_s N002_43 N002_43_M9_43_s 0.01
R_VDD_M9_43_b VDD VDD_M9_43_b 0.01
M9_43 VDD_M9_43_d C_43_M9_43_g N002_43_M9_43_s VDD_M9_43_b pmos l=1u w=4u
R_VDD_M10_43_d VDD VDD_M10_43_d 0.01
R_A_43_M10_43_g A_43 A_43_M10_43_g 0.01
R_N004_43_M10_43_s N004_43 N004_43_M10_43_s 0.01
R_VDD_M10_43_b VDD VDD_M10_43_b 0.01
M10_43 VDD_M10_43_d A_43_M10_43_g N004_43_M10_43_s VDD_M10_43_b pmos l=1u w=8u
R_N004_43_M11_43_d N004_43 N004_43_M11_43_d 0.01
R_B_43_M11_43_g B_43 B_43_M11_43_g 0.01
R_N006_43_M11_43_s N006_43 N006_43_M11_43_s 0.01
R_VDD_M11_43_b VDD VDD_M11_43_b 0.01
M11_43 N004_43_M11_43_d B_43_M11_43_g N006_43_M11_43_s VDD_M11_43_b pmos l=1u w=8u
R_N006_43_M12_43_d N006_43 N006_43_M12_43_d 0.01
R_C_43_M12_43_g C_43 C_43_M12_43_g 0.01
R_N007_43_M12_43_s N007_43 N007_43_M12_43_s 0.01
R_VDD_M12_43_b VDD VDD_M12_43_b 0.01
M12_43 N006_43_M12_43_d C_43_M12_43_g N007_43_M12_43_s VDD_M12_43_b pmos l=1u w=8u
R_N007_43_M13_43_d N007_43 N007_43_M13_43_d 0.01
R_C_43_M13_43_g C_43 C_43_M13_43_g 0.01
R_N008_43_M13_43_s N008_43 N008_43_M13_43_s 0.01
M13_43 N007_43_M13_43_d C_43_M13_43_g N008_43_M13_43_s 0 nmos l=1u w=8u
R_N008_43_M14_43_d N008_43 N008_43_M14_43_d 0.01
R_B_43_M14_43_g B_43 B_43_M14_43_g 0.01
R_N012_43_M14_43_s N012_43 N012_43_M14_43_s 0.01
M14_43 N008_43_M14_43_d B_43_M14_43_g N012_43_M14_43_s 0 nmos l=1u w=8u
R_N012_43_M15_43_d N012_43 N012_43_M15_43_d 0.01
R_A_43_M15_43_g A_43 A_43_M15_43_g 0.01
M15_43 N012_43_M15_43_d A_43_M15_43_g 0 0 nmos l=1u w=8u
R_N010_43_M16_43_d N010_43 N010_43_M16_43_d 0.01
R_C_43_M16_43_g C_43 C_43_M16_43_g 0.01
M16_43 N010_43_M16_43_d C_43_M16_43_g 0 0 nmos l=1u w=2u
R_N010_43_M17_43_d N010_43 N010_43_M17_43_d 0.01
R_B_43_M17_43_g B_43 B_43_M17_43_g 0.01
M17_43 N010_43_M17_43_d B_43_M17_43_g 0 0 nmos l=1u w=2u
R_N010_43_M18_43_d N010_43 N010_43_M18_43_d 0.01
R_A_43_M18_43_g A_43 A_43_M18_43_g 0.01
M18_43 N010_43_M18_43_d A_43_M18_43_g 0 0 nmos l=1u w=2u
R_N007_43_M19_43_d N007_43 N007_43_M19_43_d 0.01
R_N005_43_M19_43_g N005_43 N005_43_M19_43_g 0.01
R_N010_43_M19_43_s N010_43 N010_43_M19_43_s 0.01
M19_43 N007_43_M19_43_d N005_43_M19_43_g N010_43_M19_43_s 0 nmos l=1u w=2u
R_N009_43_M20_43_d N009_43 N009_43_M20_43_d 0.01
R_B_43_M20_43_g B_43 B_43_M20_43_g 0.01
M20_43 N009_43_M20_43_d B_43_M20_43_g 0 0 nmos l=1u w=2u
R_N009_43_M21_43_d N009_43 N009_43_M21_43_d 0.01
R_A_43_M21_43_g A_43 A_43_M21_43_g 0.01
M21_43 N009_43_M21_43_d A_43_M21_43_g 0 0 nmos l=1u w=2u
R_N011_43_M22_43_d N011_43 N011_43_M22_43_d 0.01
R_A_43_M22_43_g A_43 A_43_M22_43_g 0.01
M22_43 N011_43_M22_43_d A_43_M22_43_g 0 0 nmos l=1u w=2u
R_N005_43_M23_43_d N005_43 N005_43_M23_43_d 0.01
R_B_43_M23_43_g B_43 B_43_M23_43_g 0.01
R_N011_43_M23_43_s N011_43 N011_43_M23_43_s 0.01
M23_43 N005_43_M23_43_d B_43_M23_43_g N011_43_M23_43_s 0 nmos l=1u w=2u
R_N005_43_M24_43_d N005_43 N005_43_M24_43_d 0.01
R_C_43_M24_43_g C_43 C_43_M24_43_g 0.01
R_N009_43_M24_43_s N009_43 N009_43_M24_43_s 0.01
M24_43 N005_43_M24_43_d C_43_M24_43_g N009_43_M24_43_s 0 nmos l=1u w=2u
R_C_44_M25_43_d C_44 C_44_M25_43_d 0.01
R_N005_43_M25_43_g N005_43 N005_43_M25_43_g 0.01
M25_43 C_44_M25_43_d N005_43_M25_43_g 0 0 nmos l=1u w=1u
R_N002_43_M26_43_d N002_43 N002_43_M26_43_d 0.01
R_N005_43_M26_43_g N005_43 N005_43_M26_43_g 0.01
R_N007_43_M26_43_s N007_43 N007_43_M26_43_s 0.01
R_VDD_M26_43_b VDD VDD_M26_43_b 0.01
M26_43 N002_43_M26_43_d N005_43_M26_43_g N007_43_M26_43_s VDD_M26_43_b pmos l=1u w=4u
R_VDD_M27_43_d VDD VDD_M27_43_d 0.01
R_N007_43_M27_43_g N007_43 N007_43_M27_43_g 0.01
R_S_43_M27_43_s S_43 S_43_M27_43_s 0.01
R_VDD_M27_43_b VDD VDD_M27_43_b 0.01
M27_43 VDD_M27_43_d N007_43_M27_43_g S_43_M27_43_s VDD_M27_43_b pmos l=1u w=2u
R_S_43_M28_43_d S_43 S_43_M28_43_d 0.01
R_N007_43_M28_43_g N007_43 N007_43_M28_43_g 0.01
M28_43 S_43_M28_43_d N007_43_M28_43_g 0 0 nmos l=1u w=1u
C_S_43 S_43 0 1f
* --- Bit 44 ---
R_VDD_M1_44_d VDD VDD_M1_44_d 0.01
R_A_44_M1_44_g A_44 A_44_M1_44_g 0.01
R_N003_44_M1_44_s N003_44 N003_44_M1_44_s 0.01
R_VDD_M1_44_b VDD VDD_M1_44_b 0.01
M1_44 VDD_M1_44_d A_44_M1_44_g N003_44_M1_44_s VDD_M1_44_b pmos l=1u w=4u
R_N003_44_M2_44_d N003_44 N003_44_M2_44_d 0.01
R_B_44_M2_44_g B_44 B_44_M2_44_g 0.01
R_N005_44_M2_44_s N005_44 N005_44_M2_44_s 0.01
R_VDD_M2_44_b VDD VDD_M2_44_b 0.01
M2_44 N003_44_M2_44_d B_44_M2_44_g N005_44_M2_44_s VDD_M2_44_b pmos l=1u w=4u
R_VDD_M3_44_d VDD VDD_M3_44_d 0.01
R_A_44_M3_44_g A_44 A_44_M3_44_g 0.01
R_N001_44_M3_44_s N001_44 N001_44_M3_44_s 0.01
R_VDD_M3_44_b VDD VDD_M3_44_b 0.01
M3_44 VDD_M3_44_d A_44_M3_44_g N001_44_M3_44_s VDD_M3_44_b pmos l=1u w=4u
R_N001_44_M4_44_d N001_44 N001_44_M4_44_d 0.01
R_C_44_M4_44_g C_44 C_44_M4_44_g 0.01
R_N005_44_M4_44_s N005_44 N005_44_M4_44_s 0.01
R_VDD_M4_44_b VDD VDD_M4_44_b 0.01
M4_44 N001_44_M4_44_d C_44_M4_44_g N005_44_M4_44_s VDD_M4_44_b pmos l=1u w=4u
R_VDD_M5_44_d VDD VDD_M5_44_d 0.01
R_B_44_M5_44_g B_44 B_44_M5_44_g 0.01
R_N001_44_M5_44_s N001_44 N001_44_M5_44_s 0.01
R_VDD_M5_44_b VDD VDD_M5_44_b 0.01
M5_44 VDD_M5_44_d B_44_M5_44_g N001_44_M5_44_s VDD_M5_44_b pmos l=1u w=4u
R_VDD_M6_44_d VDD VDD_M6_44_d 0.01
R_N005_44_M6_44_g N005_44 N005_44_M6_44_g 0.01
R_C_45_M6_44_s C_45 C_45_M6_44_s 0.01
R_VDD_M6_44_b VDD VDD_M6_44_b 0.01
M6_44 VDD_M6_44_d N005_44_M6_44_g C_45_M6_44_s VDD_M6_44_b pmos l=1u w=2u
R_VDD_M7_44_d VDD VDD_M7_44_d 0.01
R_A_44_M7_44_g A_44 A_44_M7_44_g 0.01
R_N002_44_M7_44_s N002_44 N002_44_M7_44_s 0.01
R_VDD_M7_44_b VDD VDD_M7_44_b 0.01
M7_44 VDD_M7_44_d A_44_M7_44_g N002_44_M7_44_s VDD_M7_44_b pmos l=1u w=4u
R_VDD_M8_44_d VDD VDD_M8_44_d 0.01
R_B_44_M8_44_g B_44 B_44_M8_44_g 0.01
R_N002_44_M8_44_s N002_44 N002_44_M8_44_s 0.01
R_VDD_M8_44_b VDD VDD_M8_44_b 0.01
M8_44 VDD_M8_44_d B_44_M8_44_g N002_44_M8_44_s VDD_M8_44_b pmos l=1u w=4u
R_VDD_M9_44_d VDD VDD_M9_44_d 0.01
R_C_44_M9_44_g C_44 C_44_M9_44_g 0.01
R_N002_44_M9_44_s N002_44 N002_44_M9_44_s 0.01
R_VDD_M9_44_b VDD VDD_M9_44_b 0.01
M9_44 VDD_M9_44_d C_44_M9_44_g N002_44_M9_44_s VDD_M9_44_b pmos l=1u w=4u
R_VDD_M10_44_d VDD VDD_M10_44_d 0.01
R_A_44_M10_44_g A_44 A_44_M10_44_g 0.01
R_N004_44_M10_44_s N004_44 N004_44_M10_44_s 0.01
R_VDD_M10_44_b VDD VDD_M10_44_b 0.01
M10_44 VDD_M10_44_d A_44_M10_44_g N004_44_M10_44_s VDD_M10_44_b pmos l=1u w=8u
R_N004_44_M11_44_d N004_44 N004_44_M11_44_d 0.01
R_B_44_M11_44_g B_44 B_44_M11_44_g 0.01
R_N006_44_M11_44_s N006_44 N006_44_M11_44_s 0.01
R_VDD_M11_44_b VDD VDD_M11_44_b 0.01
M11_44 N004_44_M11_44_d B_44_M11_44_g N006_44_M11_44_s VDD_M11_44_b pmos l=1u w=8u
R_N006_44_M12_44_d N006_44 N006_44_M12_44_d 0.01
R_C_44_M12_44_g C_44 C_44_M12_44_g 0.01
R_N007_44_M12_44_s N007_44 N007_44_M12_44_s 0.01
R_VDD_M12_44_b VDD VDD_M12_44_b 0.01
M12_44 N006_44_M12_44_d C_44_M12_44_g N007_44_M12_44_s VDD_M12_44_b pmos l=1u w=8u
R_N007_44_M13_44_d N007_44 N007_44_M13_44_d 0.01
R_C_44_M13_44_g C_44 C_44_M13_44_g 0.01
R_N008_44_M13_44_s N008_44 N008_44_M13_44_s 0.01
M13_44 N007_44_M13_44_d C_44_M13_44_g N008_44_M13_44_s 0 nmos l=1u w=8u
R_N008_44_M14_44_d N008_44 N008_44_M14_44_d 0.01
R_B_44_M14_44_g B_44 B_44_M14_44_g 0.01
R_N012_44_M14_44_s N012_44 N012_44_M14_44_s 0.01
M14_44 N008_44_M14_44_d B_44_M14_44_g N012_44_M14_44_s 0 nmos l=1u w=8u
R_N012_44_M15_44_d N012_44 N012_44_M15_44_d 0.01
R_A_44_M15_44_g A_44 A_44_M15_44_g 0.01
M15_44 N012_44_M15_44_d A_44_M15_44_g 0 0 nmos l=1u w=8u
R_N010_44_M16_44_d N010_44 N010_44_M16_44_d 0.01
R_C_44_M16_44_g C_44 C_44_M16_44_g 0.01
M16_44 N010_44_M16_44_d C_44_M16_44_g 0 0 nmos l=1u w=2u
R_N010_44_M17_44_d N010_44 N010_44_M17_44_d 0.01
R_B_44_M17_44_g B_44 B_44_M17_44_g 0.01
M17_44 N010_44_M17_44_d B_44_M17_44_g 0 0 nmos l=1u w=2u
R_N010_44_M18_44_d N010_44 N010_44_M18_44_d 0.01
R_A_44_M18_44_g A_44 A_44_M18_44_g 0.01
M18_44 N010_44_M18_44_d A_44_M18_44_g 0 0 nmos l=1u w=2u
R_N007_44_M19_44_d N007_44 N007_44_M19_44_d 0.01
R_N005_44_M19_44_g N005_44 N005_44_M19_44_g 0.01
R_N010_44_M19_44_s N010_44 N010_44_M19_44_s 0.01
M19_44 N007_44_M19_44_d N005_44_M19_44_g N010_44_M19_44_s 0 nmos l=1u w=2u
R_N009_44_M20_44_d N009_44 N009_44_M20_44_d 0.01
R_B_44_M20_44_g B_44 B_44_M20_44_g 0.01
M20_44 N009_44_M20_44_d B_44_M20_44_g 0 0 nmos l=1u w=2u
R_N009_44_M21_44_d N009_44 N009_44_M21_44_d 0.01
R_A_44_M21_44_g A_44 A_44_M21_44_g 0.01
M21_44 N009_44_M21_44_d A_44_M21_44_g 0 0 nmos l=1u w=2u
R_N011_44_M22_44_d N011_44 N011_44_M22_44_d 0.01
R_A_44_M22_44_g A_44 A_44_M22_44_g 0.01
M22_44 N011_44_M22_44_d A_44_M22_44_g 0 0 nmos l=1u w=2u
R_N005_44_M23_44_d N005_44 N005_44_M23_44_d 0.01
R_B_44_M23_44_g B_44 B_44_M23_44_g 0.01
R_N011_44_M23_44_s N011_44 N011_44_M23_44_s 0.01
M23_44 N005_44_M23_44_d B_44_M23_44_g N011_44_M23_44_s 0 nmos l=1u w=2u
R_N005_44_M24_44_d N005_44 N005_44_M24_44_d 0.01
R_C_44_M24_44_g C_44 C_44_M24_44_g 0.01
R_N009_44_M24_44_s N009_44 N009_44_M24_44_s 0.01
M24_44 N005_44_M24_44_d C_44_M24_44_g N009_44_M24_44_s 0 nmos l=1u w=2u
R_C_45_M25_44_d C_45 C_45_M25_44_d 0.01
R_N005_44_M25_44_g N005_44 N005_44_M25_44_g 0.01
M25_44 C_45_M25_44_d N005_44_M25_44_g 0 0 nmos l=1u w=1u
R_N002_44_M26_44_d N002_44 N002_44_M26_44_d 0.01
R_N005_44_M26_44_g N005_44 N005_44_M26_44_g 0.01
R_N007_44_M26_44_s N007_44 N007_44_M26_44_s 0.01
R_VDD_M26_44_b VDD VDD_M26_44_b 0.01
M26_44 N002_44_M26_44_d N005_44_M26_44_g N007_44_M26_44_s VDD_M26_44_b pmos l=1u w=4u
R_VDD_M27_44_d VDD VDD_M27_44_d 0.01
R_N007_44_M27_44_g N007_44 N007_44_M27_44_g 0.01
R_S_44_M27_44_s S_44 S_44_M27_44_s 0.01
R_VDD_M27_44_b VDD VDD_M27_44_b 0.01
M27_44 VDD_M27_44_d N007_44_M27_44_g S_44_M27_44_s VDD_M27_44_b pmos l=1u w=2u
R_S_44_M28_44_d S_44 S_44_M28_44_d 0.01
R_N007_44_M28_44_g N007_44 N007_44_M28_44_g 0.01
M28_44 S_44_M28_44_d N007_44_M28_44_g 0 0 nmos l=1u w=1u
C_S_44 S_44 0 1f
* --- Bit 45 ---
R_VDD_M1_45_d VDD VDD_M1_45_d 0.01
R_A_45_M1_45_g A_45 A_45_M1_45_g 0.01
R_N003_45_M1_45_s N003_45 N003_45_M1_45_s 0.01
R_VDD_M1_45_b VDD VDD_M1_45_b 0.01
M1_45 VDD_M1_45_d A_45_M1_45_g N003_45_M1_45_s VDD_M1_45_b pmos l=1u w=4u
R_N003_45_M2_45_d N003_45 N003_45_M2_45_d 0.01
R_B_45_M2_45_g B_45 B_45_M2_45_g 0.01
R_N005_45_M2_45_s N005_45 N005_45_M2_45_s 0.01
R_VDD_M2_45_b VDD VDD_M2_45_b 0.01
M2_45 N003_45_M2_45_d B_45_M2_45_g N005_45_M2_45_s VDD_M2_45_b pmos l=1u w=4u
R_VDD_M3_45_d VDD VDD_M3_45_d 0.01
R_A_45_M3_45_g A_45 A_45_M3_45_g 0.01
R_N001_45_M3_45_s N001_45 N001_45_M3_45_s 0.01
R_VDD_M3_45_b VDD VDD_M3_45_b 0.01
M3_45 VDD_M3_45_d A_45_M3_45_g N001_45_M3_45_s VDD_M3_45_b pmos l=1u w=4u
R_N001_45_M4_45_d N001_45 N001_45_M4_45_d 0.01
R_C_45_M4_45_g C_45 C_45_M4_45_g 0.01
R_N005_45_M4_45_s N005_45 N005_45_M4_45_s 0.01
R_VDD_M4_45_b VDD VDD_M4_45_b 0.01
M4_45 N001_45_M4_45_d C_45_M4_45_g N005_45_M4_45_s VDD_M4_45_b pmos l=1u w=4u
R_VDD_M5_45_d VDD VDD_M5_45_d 0.01
R_B_45_M5_45_g B_45 B_45_M5_45_g 0.01
R_N001_45_M5_45_s N001_45 N001_45_M5_45_s 0.01
R_VDD_M5_45_b VDD VDD_M5_45_b 0.01
M5_45 VDD_M5_45_d B_45_M5_45_g N001_45_M5_45_s VDD_M5_45_b pmos l=1u w=4u
R_VDD_M6_45_d VDD VDD_M6_45_d 0.01
R_N005_45_M6_45_g N005_45 N005_45_M6_45_g 0.01
R_C_46_M6_45_s C_46 C_46_M6_45_s 0.01
R_VDD_M6_45_b VDD VDD_M6_45_b 0.01
M6_45 VDD_M6_45_d N005_45_M6_45_g C_46_M6_45_s VDD_M6_45_b pmos l=1u w=2u
R_VDD_M7_45_d VDD VDD_M7_45_d 0.01
R_A_45_M7_45_g A_45 A_45_M7_45_g 0.01
R_N002_45_M7_45_s N002_45 N002_45_M7_45_s 0.01
R_VDD_M7_45_b VDD VDD_M7_45_b 0.01
M7_45 VDD_M7_45_d A_45_M7_45_g N002_45_M7_45_s VDD_M7_45_b pmos l=1u w=4u
R_VDD_M8_45_d VDD VDD_M8_45_d 0.01
R_B_45_M8_45_g B_45 B_45_M8_45_g 0.01
R_N002_45_M8_45_s N002_45 N002_45_M8_45_s 0.01
R_VDD_M8_45_b VDD VDD_M8_45_b 0.01
M8_45 VDD_M8_45_d B_45_M8_45_g N002_45_M8_45_s VDD_M8_45_b pmos l=1u w=4u
R_VDD_M9_45_d VDD VDD_M9_45_d 0.01
R_C_45_M9_45_g C_45 C_45_M9_45_g 0.01
R_N002_45_M9_45_s N002_45 N002_45_M9_45_s 0.01
R_VDD_M9_45_b VDD VDD_M9_45_b 0.01
M9_45 VDD_M9_45_d C_45_M9_45_g N002_45_M9_45_s VDD_M9_45_b pmos l=1u w=4u
R_VDD_M10_45_d VDD VDD_M10_45_d 0.01
R_A_45_M10_45_g A_45 A_45_M10_45_g 0.01
R_N004_45_M10_45_s N004_45 N004_45_M10_45_s 0.01
R_VDD_M10_45_b VDD VDD_M10_45_b 0.01
M10_45 VDD_M10_45_d A_45_M10_45_g N004_45_M10_45_s VDD_M10_45_b pmos l=1u w=8u
R_N004_45_M11_45_d N004_45 N004_45_M11_45_d 0.01
R_B_45_M11_45_g B_45 B_45_M11_45_g 0.01
R_N006_45_M11_45_s N006_45 N006_45_M11_45_s 0.01
R_VDD_M11_45_b VDD VDD_M11_45_b 0.01
M11_45 N004_45_M11_45_d B_45_M11_45_g N006_45_M11_45_s VDD_M11_45_b pmos l=1u w=8u
R_N006_45_M12_45_d N006_45 N006_45_M12_45_d 0.01
R_C_45_M12_45_g C_45 C_45_M12_45_g 0.01
R_N007_45_M12_45_s N007_45 N007_45_M12_45_s 0.01
R_VDD_M12_45_b VDD VDD_M12_45_b 0.01
M12_45 N006_45_M12_45_d C_45_M12_45_g N007_45_M12_45_s VDD_M12_45_b pmos l=1u w=8u
R_N007_45_M13_45_d N007_45 N007_45_M13_45_d 0.01
R_C_45_M13_45_g C_45 C_45_M13_45_g 0.01
R_N008_45_M13_45_s N008_45 N008_45_M13_45_s 0.01
M13_45 N007_45_M13_45_d C_45_M13_45_g N008_45_M13_45_s 0 nmos l=1u w=8u
R_N008_45_M14_45_d N008_45 N008_45_M14_45_d 0.01
R_B_45_M14_45_g B_45 B_45_M14_45_g 0.01
R_N012_45_M14_45_s N012_45 N012_45_M14_45_s 0.01
M14_45 N008_45_M14_45_d B_45_M14_45_g N012_45_M14_45_s 0 nmos l=1u w=8u
R_N012_45_M15_45_d N012_45 N012_45_M15_45_d 0.01
R_A_45_M15_45_g A_45 A_45_M15_45_g 0.01
M15_45 N012_45_M15_45_d A_45_M15_45_g 0 0 nmos l=1u w=8u
R_N010_45_M16_45_d N010_45 N010_45_M16_45_d 0.01
R_C_45_M16_45_g C_45 C_45_M16_45_g 0.01
M16_45 N010_45_M16_45_d C_45_M16_45_g 0 0 nmos l=1u w=2u
R_N010_45_M17_45_d N010_45 N010_45_M17_45_d 0.01
R_B_45_M17_45_g B_45 B_45_M17_45_g 0.01
M17_45 N010_45_M17_45_d B_45_M17_45_g 0 0 nmos l=1u w=2u
R_N010_45_M18_45_d N010_45 N010_45_M18_45_d 0.01
R_A_45_M18_45_g A_45 A_45_M18_45_g 0.01
M18_45 N010_45_M18_45_d A_45_M18_45_g 0 0 nmos l=1u w=2u
R_N007_45_M19_45_d N007_45 N007_45_M19_45_d 0.01
R_N005_45_M19_45_g N005_45 N005_45_M19_45_g 0.01
R_N010_45_M19_45_s N010_45 N010_45_M19_45_s 0.01
M19_45 N007_45_M19_45_d N005_45_M19_45_g N010_45_M19_45_s 0 nmos l=1u w=2u
R_N009_45_M20_45_d N009_45 N009_45_M20_45_d 0.01
R_B_45_M20_45_g B_45 B_45_M20_45_g 0.01
M20_45 N009_45_M20_45_d B_45_M20_45_g 0 0 nmos l=1u w=2u
R_N009_45_M21_45_d N009_45 N009_45_M21_45_d 0.01
R_A_45_M21_45_g A_45 A_45_M21_45_g 0.01
M21_45 N009_45_M21_45_d A_45_M21_45_g 0 0 nmos l=1u w=2u
R_N011_45_M22_45_d N011_45 N011_45_M22_45_d 0.01
R_A_45_M22_45_g A_45 A_45_M22_45_g 0.01
M22_45 N011_45_M22_45_d A_45_M22_45_g 0 0 nmos l=1u w=2u
R_N005_45_M23_45_d N005_45 N005_45_M23_45_d 0.01
R_B_45_M23_45_g B_45 B_45_M23_45_g 0.01
R_N011_45_M23_45_s N011_45 N011_45_M23_45_s 0.01
M23_45 N005_45_M23_45_d B_45_M23_45_g N011_45_M23_45_s 0 nmos l=1u w=2u
R_N005_45_M24_45_d N005_45 N005_45_M24_45_d 0.01
R_C_45_M24_45_g C_45 C_45_M24_45_g 0.01
R_N009_45_M24_45_s N009_45 N009_45_M24_45_s 0.01
M24_45 N005_45_M24_45_d C_45_M24_45_g N009_45_M24_45_s 0 nmos l=1u w=2u
R_C_46_M25_45_d C_46 C_46_M25_45_d 0.01
R_N005_45_M25_45_g N005_45 N005_45_M25_45_g 0.01
M25_45 C_46_M25_45_d N005_45_M25_45_g 0 0 nmos l=1u w=1u
R_N002_45_M26_45_d N002_45 N002_45_M26_45_d 0.01
R_N005_45_M26_45_g N005_45 N005_45_M26_45_g 0.01
R_N007_45_M26_45_s N007_45 N007_45_M26_45_s 0.01
R_VDD_M26_45_b VDD VDD_M26_45_b 0.01
M26_45 N002_45_M26_45_d N005_45_M26_45_g N007_45_M26_45_s VDD_M26_45_b pmos l=1u w=4u
R_VDD_M27_45_d VDD VDD_M27_45_d 0.01
R_N007_45_M27_45_g N007_45 N007_45_M27_45_g 0.01
R_S_45_M27_45_s S_45 S_45_M27_45_s 0.01
R_VDD_M27_45_b VDD VDD_M27_45_b 0.01
M27_45 VDD_M27_45_d N007_45_M27_45_g S_45_M27_45_s VDD_M27_45_b pmos l=1u w=2u
R_S_45_M28_45_d S_45 S_45_M28_45_d 0.01
R_N007_45_M28_45_g N007_45 N007_45_M28_45_g 0.01
M28_45 S_45_M28_45_d N007_45_M28_45_g 0 0 nmos l=1u w=1u
C_S_45 S_45 0 1f
* --- Bit 46 ---
R_VDD_M1_46_d VDD VDD_M1_46_d 0.01
R_A_46_M1_46_g A_46 A_46_M1_46_g 0.01
R_N003_46_M1_46_s N003_46 N003_46_M1_46_s 0.01
R_VDD_M1_46_b VDD VDD_M1_46_b 0.01
M1_46 VDD_M1_46_d A_46_M1_46_g N003_46_M1_46_s VDD_M1_46_b pmos l=1u w=4u
R_N003_46_M2_46_d N003_46 N003_46_M2_46_d 0.01
R_B_46_M2_46_g B_46 B_46_M2_46_g 0.01
R_N005_46_M2_46_s N005_46 N005_46_M2_46_s 0.01
R_VDD_M2_46_b VDD VDD_M2_46_b 0.01
M2_46 N003_46_M2_46_d B_46_M2_46_g N005_46_M2_46_s VDD_M2_46_b pmos l=1u w=4u
R_VDD_M3_46_d VDD VDD_M3_46_d 0.01
R_A_46_M3_46_g A_46 A_46_M3_46_g 0.01
R_N001_46_M3_46_s N001_46 N001_46_M3_46_s 0.01
R_VDD_M3_46_b VDD VDD_M3_46_b 0.01
M3_46 VDD_M3_46_d A_46_M3_46_g N001_46_M3_46_s VDD_M3_46_b pmos l=1u w=4u
R_N001_46_M4_46_d N001_46 N001_46_M4_46_d 0.01
R_C_46_M4_46_g C_46 C_46_M4_46_g 0.01
R_N005_46_M4_46_s N005_46 N005_46_M4_46_s 0.01
R_VDD_M4_46_b VDD VDD_M4_46_b 0.01
M4_46 N001_46_M4_46_d C_46_M4_46_g N005_46_M4_46_s VDD_M4_46_b pmos l=1u w=4u
R_VDD_M5_46_d VDD VDD_M5_46_d 0.01
R_B_46_M5_46_g B_46 B_46_M5_46_g 0.01
R_N001_46_M5_46_s N001_46 N001_46_M5_46_s 0.01
R_VDD_M5_46_b VDD VDD_M5_46_b 0.01
M5_46 VDD_M5_46_d B_46_M5_46_g N001_46_M5_46_s VDD_M5_46_b pmos l=1u w=4u
R_VDD_M6_46_d VDD VDD_M6_46_d 0.01
R_N005_46_M6_46_g N005_46 N005_46_M6_46_g 0.01
R_C_47_M6_46_s C_47 C_47_M6_46_s 0.01
R_VDD_M6_46_b VDD VDD_M6_46_b 0.01
M6_46 VDD_M6_46_d N005_46_M6_46_g C_47_M6_46_s VDD_M6_46_b pmos l=1u w=2u
R_VDD_M7_46_d VDD VDD_M7_46_d 0.01
R_A_46_M7_46_g A_46 A_46_M7_46_g 0.01
R_N002_46_M7_46_s N002_46 N002_46_M7_46_s 0.01
R_VDD_M7_46_b VDD VDD_M7_46_b 0.01
M7_46 VDD_M7_46_d A_46_M7_46_g N002_46_M7_46_s VDD_M7_46_b pmos l=1u w=4u
R_VDD_M8_46_d VDD VDD_M8_46_d 0.01
R_B_46_M8_46_g B_46 B_46_M8_46_g 0.01
R_N002_46_M8_46_s N002_46 N002_46_M8_46_s 0.01
R_VDD_M8_46_b VDD VDD_M8_46_b 0.01
M8_46 VDD_M8_46_d B_46_M8_46_g N002_46_M8_46_s VDD_M8_46_b pmos l=1u w=4u
R_VDD_M9_46_d VDD VDD_M9_46_d 0.01
R_C_46_M9_46_g C_46 C_46_M9_46_g 0.01
R_N002_46_M9_46_s N002_46 N002_46_M9_46_s 0.01
R_VDD_M9_46_b VDD VDD_M9_46_b 0.01
M9_46 VDD_M9_46_d C_46_M9_46_g N002_46_M9_46_s VDD_M9_46_b pmos l=1u w=4u
R_VDD_M10_46_d VDD VDD_M10_46_d 0.01
R_A_46_M10_46_g A_46 A_46_M10_46_g 0.01
R_N004_46_M10_46_s N004_46 N004_46_M10_46_s 0.01
R_VDD_M10_46_b VDD VDD_M10_46_b 0.01
M10_46 VDD_M10_46_d A_46_M10_46_g N004_46_M10_46_s VDD_M10_46_b pmos l=1u w=8u
R_N004_46_M11_46_d N004_46 N004_46_M11_46_d 0.01
R_B_46_M11_46_g B_46 B_46_M11_46_g 0.01
R_N006_46_M11_46_s N006_46 N006_46_M11_46_s 0.01
R_VDD_M11_46_b VDD VDD_M11_46_b 0.01
M11_46 N004_46_M11_46_d B_46_M11_46_g N006_46_M11_46_s VDD_M11_46_b pmos l=1u w=8u
R_N006_46_M12_46_d N006_46 N006_46_M12_46_d 0.01
R_C_46_M12_46_g C_46 C_46_M12_46_g 0.01
R_N007_46_M12_46_s N007_46 N007_46_M12_46_s 0.01
R_VDD_M12_46_b VDD VDD_M12_46_b 0.01
M12_46 N006_46_M12_46_d C_46_M12_46_g N007_46_M12_46_s VDD_M12_46_b pmos l=1u w=8u
R_N007_46_M13_46_d N007_46 N007_46_M13_46_d 0.01
R_C_46_M13_46_g C_46 C_46_M13_46_g 0.01
R_N008_46_M13_46_s N008_46 N008_46_M13_46_s 0.01
M13_46 N007_46_M13_46_d C_46_M13_46_g N008_46_M13_46_s 0 nmos l=1u w=8u
R_N008_46_M14_46_d N008_46 N008_46_M14_46_d 0.01
R_B_46_M14_46_g B_46 B_46_M14_46_g 0.01
R_N012_46_M14_46_s N012_46 N012_46_M14_46_s 0.01
M14_46 N008_46_M14_46_d B_46_M14_46_g N012_46_M14_46_s 0 nmos l=1u w=8u
R_N012_46_M15_46_d N012_46 N012_46_M15_46_d 0.01
R_A_46_M15_46_g A_46 A_46_M15_46_g 0.01
M15_46 N012_46_M15_46_d A_46_M15_46_g 0 0 nmos l=1u w=8u
R_N010_46_M16_46_d N010_46 N010_46_M16_46_d 0.01
R_C_46_M16_46_g C_46 C_46_M16_46_g 0.01
M16_46 N010_46_M16_46_d C_46_M16_46_g 0 0 nmos l=1u w=2u
R_N010_46_M17_46_d N010_46 N010_46_M17_46_d 0.01
R_B_46_M17_46_g B_46 B_46_M17_46_g 0.01
M17_46 N010_46_M17_46_d B_46_M17_46_g 0 0 nmos l=1u w=2u
R_N010_46_M18_46_d N010_46 N010_46_M18_46_d 0.01
R_A_46_M18_46_g A_46 A_46_M18_46_g 0.01
M18_46 N010_46_M18_46_d A_46_M18_46_g 0 0 nmos l=1u w=2u
R_N007_46_M19_46_d N007_46 N007_46_M19_46_d 0.01
R_N005_46_M19_46_g N005_46 N005_46_M19_46_g 0.01
R_N010_46_M19_46_s N010_46 N010_46_M19_46_s 0.01
M19_46 N007_46_M19_46_d N005_46_M19_46_g N010_46_M19_46_s 0 nmos l=1u w=2u
R_N009_46_M20_46_d N009_46 N009_46_M20_46_d 0.01
R_B_46_M20_46_g B_46 B_46_M20_46_g 0.01
M20_46 N009_46_M20_46_d B_46_M20_46_g 0 0 nmos l=1u w=2u
R_N009_46_M21_46_d N009_46 N009_46_M21_46_d 0.01
R_A_46_M21_46_g A_46 A_46_M21_46_g 0.01
M21_46 N009_46_M21_46_d A_46_M21_46_g 0 0 nmos l=1u w=2u
R_N011_46_M22_46_d N011_46 N011_46_M22_46_d 0.01
R_A_46_M22_46_g A_46 A_46_M22_46_g 0.01
M22_46 N011_46_M22_46_d A_46_M22_46_g 0 0 nmos l=1u w=2u
R_N005_46_M23_46_d N005_46 N005_46_M23_46_d 0.01
R_B_46_M23_46_g B_46 B_46_M23_46_g 0.01
R_N011_46_M23_46_s N011_46 N011_46_M23_46_s 0.01
M23_46 N005_46_M23_46_d B_46_M23_46_g N011_46_M23_46_s 0 nmos l=1u w=2u
R_N005_46_M24_46_d N005_46 N005_46_M24_46_d 0.01
R_C_46_M24_46_g C_46 C_46_M24_46_g 0.01
R_N009_46_M24_46_s N009_46 N009_46_M24_46_s 0.01
M24_46 N005_46_M24_46_d C_46_M24_46_g N009_46_M24_46_s 0 nmos l=1u w=2u
R_C_47_M25_46_d C_47 C_47_M25_46_d 0.01
R_N005_46_M25_46_g N005_46 N005_46_M25_46_g 0.01
M25_46 C_47_M25_46_d N005_46_M25_46_g 0 0 nmos l=1u w=1u
R_N002_46_M26_46_d N002_46 N002_46_M26_46_d 0.01
R_N005_46_M26_46_g N005_46 N005_46_M26_46_g 0.01
R_N007_46_M26_46_s N007_46 N007_46_M26_46_s 0.01
R_VDD_M26_46_b VDD VDD_M26_46_b 0.01
M26_46 N002_46_M26_46_d N005_46_M26_46_g N007_46_M26_46_s VDD_M26_46_b pmos l=1u w=4u
R_VDD_M27_46_d VDD VDD_M27_46_d 0.01
R_N007_46_M27_46_g N007_46 N007_46_M27_46_g 0.01
R_S_46_M27_46_s S_46 S_46_M27_46_s 0.01
R_VDD_M27_46_b VDD VDD_M27_46_b 0.01
M27_46 VDD_M27_46_d N007_46_M27_46_g S_46_M27_46_s VDD_M27_46_b pmos l=1u w=2u
R_S_46_M28_46_d S_46 S_46_M28_46_d 0.01
R_N007_46_M28_46_g N007_46 N007_46_M28_46_g 0.01
M28_46 S_46_M28_46_d N007_46_M28_46_g 0 0 nmos l=1u w=1u
C_S_46 S_46 0 1f
* --- Bit 47 ---
R_VDD_M1_47_d VDD VDD_M1_47_d 0.01
R_A_47_M1_47_g A_47 A_47_M1_47_g 0.01
R_N003_47_M1_47_s N003_47 N003_47_M1_47_s 0.01
R_VDD_M1_47_b VDD VDD_M1_47_b 0.01
M1_47 VDD_M1_47_d A_47_M1_47_g N003_47_M1_47_s VDD_M1_47_b pmos l=1u w=4u
R_N003_47_M2_47_d N003_47 N003_47_M2_47_d 0.01
R_B_47_M2_47_g B_47 B_47_M2_47_g 0.01
R_N005_47_M2_47_s N005_47 N005_47_M2_47_s 0.01
R_VDD_M2_47_b VDD VDD_M2_47_b 0.01
M2_47 N003_47_M2_47_d B_47_M2_47_g N005_47_M2_47_s VDD_M2_47_b pmos l=1u w=4u
R_VDD_M3_47_d VDD VDD_M3_47_d 0.01
R_A_47_M3_47_g A_47 A_47_M3_47_g 0.01
R_N001_47_M3_47_s N001_47 N001_47_M3_47_s 0.01
R_VDD_M3_47_b VDD VDD_M3_47_b 0.01
M3_47 VDD_M3_47_d A_47_M3_47_g N001_47_M3_47_s VDD_M3_47_b pmos l=1u w=4u
R_N001_47_M4_47_d N001_47 N001_47_M4_47_d 0.01
R_C_47_M4_47_g C_47 C_47_M4_47_g 0.01
R_N005_47_M4_47_s N005_47 N005_47_M4_47_s 0.01
R_VDD_M4_47_b VDD VDD_M4_47_b 0.01
M4_47 N001_47_M4_47_d C_47_M4_47_g N005_47_M4_47_s VDD_M4_47_b pmos l=1u w=4u
R_VDD_M5_47_d VDD VDD_M5_47_d 0.01
R_B_47_M5_47_g B_47 B_47_M5_47_g 0.01
R_N001_47_M5_47_s N001_47 N001_47_M5_47_s 0.01
R_VDD_M5_47_b VDD VDD_M5_47_b 0.01
M5_47 VDD_M5_47_d B_47_M5_47_g N001_47_M5_47_s VDD_M5_47_b pmos l=1u w=4u
R_VDD_M6_47_d VDD VDD_M6_47_d 0.01
R_N005_47_M6_47_g N005_47 N005_47_M6_47_g 0.01
R_C_48_M6_47_s C_48 C_48_M6_47_s 0.01
R_VDD_M6_47_b VDD VDD_M6_47_b 0.01
M6_47 VDD_M6_47_d N005_47_M6_47_g C_48_M6_47_s VDD_M6_47_b pmos l=1u w=2u
R_VDD_M7_47_d VDD VDD_M7_47_d 0.01
R_A_47_M7_47_g A_47 A_47_M7_47_g 0.01
R_N002_47_M7_47_s N002_47 N002_47_M7_47_s 0.01
R_VDD_M7_47_b VDD VDD_M7_47_b 0.01
M7_47 VDD_M7_47_d A_47_M7_47_g N002_47_M7_47_s VDD_M7_47_b pmos l=1u w=4u
R_VDD_M8_47_d VDD VDD_M8_47_d 0.01
R_B_47_M8_47_g B_47 B_47_M8_47_g 0.01
R_N002_47_M8_47_s N002_47 N002_47_M8_47_s 0.01
R_VDD_M8_47_b VDD VDD_M8_47_b 0.01
M8_47 VDD_M8_47_d B_47_M8_47_g N002_47_M8_47_s VDD_M8_47_b pmos l=1u w=4u
R_VDD_M9_47_d VDD VDD_M9_47_d 0.01
R_C_47_M9_47_g C_47 C_47_M9_47_g 0.01
R_N002_47_M9_47_s N002_47 N002_47_M9_47_s 0.01
R_VDD_M9_47_b VDD VDD_M9_47_b 0.01
M9_47 VDD_M9_47_d C_47_M9_47_g N002_47_M9_47_s VDD_M9_47_b pmos l=1u w=4u
R_VDD_M10_47_d VDD VDD_M10_47_d 0.01
R_A_47_M10_47_g A_47 A_47_M10_47_g 0.01
R_N004_47_M10_47_s N004_47 N004_47_M10_47_s 0.01
R_VDD_M10_47_b VDD VDD_M10_47_b 0.01
M10_47 VDD_M10_47_d A_47_M10_47_g N004_47_M10_47_s VDD_M10_47_b pmos l=1u w=8u
R_N004_47_M11_47_d N004_47 N004_47_M11_47_d 0.01
R_B_47_M11_47_g B_47 B_47_M11_47_g 0.01
R_N006_47_M11_47_s N006_47 N006_47_M11_47_s 0.01
R_VDD_M11_47_b VDD VDD_M11_47_b 0.01
M11_47 N004_47_M11_47_d B_47_M11_47_g N006_47_M11_47_s VDD_M11_47_b pmos l=1u w=8u
R_N006_47_M12_47_d N006_47 N006_47_M12_47_d 0.01
R_C_47_M12_47_g C_47 C_47_M12_47_g 0.01
R_N007_47_M12_47_s N007_47 N007_47_M12_47_s 0.01
R_VDD_M12_47_b VDD VDD_M12_47_b 0.01
M12_47 N006_47_M12_47_d C_47_M12_47_g N007_47_M12_47_s VDD_M12_47_b pmos l=1u w=8u
R_N007_47_M13_47_d N007_47 N007_47_M13_47_d 0.01
R_C_47_M13_47_g C_47 C_47_M13_47_g 0.01
R_N008_47_M13_47_s N008_47 N008_47_M13_47_s 0.01
M13_47 N007_47_M13_47_d C_47_M13_47_g N008_47_M13_47_s 0 nmos l=1u w=8u
R_N008_47_M14_47_d N008_47 N008_47_M14_47_d 0.01
R_B_47_M14_47_g B_47 B_47_M14_47_g 0.01
R_N012_47_M14_47_s N012_47 N012_47_M14_47_s 0.01
M14_47 N008_47_M14_47_d B_47_M14_47_g N012_47_M14_47_s 0 nmos l=1u w=8u
R_N012_47_M15_47_d N012_47 N012_47_M15_47_d 0.01
R_A_47_M15_47_g A_47 A_47_M15_47_g 0.01
M15_47 N012_47_M15_47_d A_47_M15_47_g 0 0 nmos l=1u w=8u
R_N010_47_M16_47_d N010_47 N010_47_M16_47_d 0.01
R_C_47_M16_47_g C_47 C_47_M16_47_g 0.01
M16_47 N010_47_M16_47_d C_47_M16_47_g 0 0 nmos l=1u w=2u
R_N010_47_M17_47_d N010_47 N010_47_M17_47_d 0.01
R_B_47_M17_47_g B_47 B_47_M17_47_g 0.01
M17_47 N010_47_M17_47_d B_47_M17_47_g 0 0 nmos l=1u w=2u
R_N010_47_M18_47_d N010_47 N010_47_M18_47_d 0.01
R_A_47_M18_47_g A_47 A_47_M18_47_g 0.01
M18_47 N010_47_M18_47_d A_47_M18_47_g 0 0 nmos l=1u w=2u
R_N007_47_M19_47_d N007_47 N007_47_M19_47_d 0.01
R_N005_47_M19_47_g N005_47 N005_47_M19_47_g 0.01
R_N010_47_M19_47_s N010_47 N010_47_M19_47_s 0.01
M19_47 N007_47_M19_47_d N005_47_M19_47_g N010_47_M19_47_s 0 nmos l=1u w=2u
R_N009_47_M20_47_d N009_47 N009_47_M20_47_d 0.01
R_B_47_M20_47_g B_47 B_47_M20_47_g 0.01
M20_47 N009_47_M20_47_d B_47_M20_47_g 0 0 nmos l=1u w=2u
R_N009_47_M21_47_d N009_47 N009_47_M21_47_d 0.01
R_A_47_M21_47_g A_47 A_47_M21_47_g 0.01
M21_47 N009_47_M21_47_d A_47_M21_47_g 0 0 nmos l=1u w=2u
R_N011_47_M22_47_d N011_47 N011_47_M22_47_d 0.01
R_A_47_M22_47_g A_47 A_47_M22_47_g 0.01
M22_47 N011_47_M22_47_d A_47_M22_47_g 0 0 nmos l=1u w=2u
R_N005_47_M23_47_d N005_47 N005_47_M23_47_d 0.01
R_B_47_M23_47_g B_47 B_47_M23_47_g 0.01
R_N011_47_M23_47_s N011_47 N011_47_M23_47_s 0.01
M23_47 N005_47_M23_47_d B_47_M23_47_g N011_47_M23_47_s 0 nmos l=1u w=2u
R_N005_47_M24_47_d N005_47 N005_47_M24_47_d 0.01
R_C_47_M24_47_g C_47 C_47_M24_47_g 0.01
R_N009_47_M24_47_s N009_47 N009_47_M24_47_s 0.01
M24_47 N005_47_M24_47_d C_47_M24_47_g N009_47_M24_47_s 0 nmos l=1u w=2u
R_C_48_M25_47_d C_48 C_48_M25_47_d 0.01
R_N005_47_M25_47_g N005_47 N005_47_M25_47_g 0.01
M25_47 C_48_M25_47_d N005_47_M25_47_g 0 0 nmos l=1u w=1u
R_N002_47_M26_47_d N002_47 N002_47_M26_47_d 0.01
R_N005_47_M26_47_g N005_47 N005_47_M26_47_g 0.01
R_N007_47_M26_47_s N007_47 N007_47_M26_47_s 0.01
R_VDD_M26_47_b VDD VDD_M26_47_b 0.01
M26_47 N002_47_M26_47_d N005_47_M26_47_g N007_47_M26_47_s VDD_M26_47_b pmos l=1u w=4u
R_VDD_M27_47_d VDD VDD_M27_47_d 0.01
R_N007_47_M27_47_g N007_47 N007_47_M27_47_g 0.01
R_S_47_M27_47_s S_47 S_47_M27_47_s 0.01
R_VDD_M27_47_b VDD VDD_M27_47_b 0.01
M27_47 VDD_M27_47_d N007_47_M27_47_g S_47_M27_47_s VDD_M27_47_b pmos l=1u w=2u
R_S_47_M28_47_d S_47 S_47_M28_47_d 0.01
R_N007_47_M28_47_g N007_47 N007_47_M28_47_g 0.01
M28_47 S_47_M28_47_d N007_47_M28_47_g 0 0 nmos l=1u w=1u
C_S_47 S_47 0 1f
* --- Bit 48 ---
R_VDD_M1_48_d VDD VDD_M1_48_d 0.01
R_A_48_M1_48_g A_48 A_48_M1_48_g 0.01
R_N003_48_M1_48_s N003_48 N003_48_M1_48_s 0.01
R_VDD_M1_48_b VDD VDD_M1_48_b 0.01
M1_48 VDD_M1_48_d A_48_M1_48_g N003_48_M1_48_s VDD_M1_48_b pmos l=1u w=4u
R_N003_48_M2_48_d N003_48 N003_48_M2_48_d 0.01
R_B_48_M2_48_g B_48 B_48_M2_48_g 0.01
R_N005_48_M2_48_s N005_48 N005_48_M2_48_s 0.01
R_VDD_M2_48_b VDD VDD_M2_48_b 0.01
M2_48 N003_48_M2_48_d B_48_M2_48_g N005_48_M2_48_s VDD_M2_48_b pmos l=1u w=4u
R_VDD_M3_48_d VDD VDD_M3_48_d 0.01
R_A_48_M3_48_g A_48 A_48_M3_48_g 0.01
R_N001_48_M3_48_s N001_48 N001_48_M3_48_s 0.01
R_VDD_M3_48_b VDD VDD_M3_48_b 0.01
M3_48 VDD_M3_48_d A_48_M3_48_g N001_48_M3_48_s VDD_M3_48_b pmos l=1u w=4u
R_N001_48_M4_48_d N001_48 N001_48_M4_48_d 0.01
R_C_48_M4_48_g C_48 C_48_M4_48_g 0.01
R_N005_48_M4_48_s N005_48 N005_48_M4_48_s 0.01
R_VDD_M4_48_b VDD VDD_M4_48_b 0.01
M4_48 N001_48_M4_48_d C_48_M4_48_g N005_48_M4_48_s VDD_M4_48_b pmos l=1u w=4u
R_VDD_M5_48_d VDD VDD_M5_48_d 0.01
R_B_48_M5_48_g B_48 B_48_M5_48_g 0.01
R_N001_48_M5_48_s N001_48 N001_48_M5_48_s 0.01
R_VDD_M5_48_b VDD VDD_M5_48_b 0.01
M5_48 VDD_M5_48_d B_48_M5_48_g N001_48_M5_48_s VDD_M5_48_b pmos l=1u w=4u
R_VDD_M6_48_d VDD VDD_M6_48_d 0.01
R_N005_48_M6_48_g N005_48 N005_48_M6_48_g 0.01
R_C_49_M6_48_s C_49 C_49_M6_48_s 0.01
R_VDD_M6_48_b VDD VDD_M6_48_b 0.01
M6_48 VDD_M6_48_d N005_48_M6_48_g C_49_M6_48_s VDD_M6_48_b pmos l=1u w=2u
R_VDD_M7_48_d VDD VDD_M7_48_d 0.01
R_A_48_M7_48_g A_48 A_48_M7_48_g 0.01
R_N002_48_M7_48_s N002_48 N002_48_M7_48_s 0.01
R_VDD_M7_48_b VDD VDD_M7_48_b 0.01
M7_48 VDD_M7_48_d A_48_M7_48_g N002_48_M7_48_s VDD_M7_48_b pmos l=1u w=4u
R_VDD_M8_48_d VDD VDD_M8_48_d 0.01
R_B_48_M8_48_g B_48 B_48_M8_48_g 0.01
R_N002_48_M8_48_s N002_48 N002_48_M8_48_s 0.01
R_VDD_M8_48_b VDD VDD_M8_48_b 0.01
M8_48 VDD_M8_48_d B_48_M8_48_g N002_48_M8_48_s VDD_M8_48_b pmos l=1u w=4u
R_VDD_M9_48_d VDD VDD_M9_48_d 0.01
R_C_48_M9_48_g C_48 C_48_M9_48_g 0.01
R_N002_48_M9_48_s N002_48 N002_48_M9_48_s 0.01
R_VDD_M9_48_b VDD VDD_M9_48_b 0.01
M9_48 VDD_M9_48_d C_48_M9_48_g N002_48_M9_48_s VDD_M9_48_b pmos l=1u w=4u
R_VDD_M10_48_d VDD VDD_M10_48_d 0.01
R_A_48_M10_48_g A_48 A_48_M10_48_g 0.01
R_N004_48_M10_48_s N004_48 N004_48_M10_48_s 0.01
R_VDD_M10_48_b VDD VDD_M10_48_b 0.01
M10_48 VDD_M10_48_d A_48_M10_48_g N004_48_M10_48_s VDD_M10_48_b pmos l=1u w=8u
R_N004_48_M11_48_d N004_48 N004_48_M11_48_d 0.01
R_B_48_M11_48_g B_48 B_48_M11_48_g 0.01
R_N006_48_M11_48_s N006_48 N006_48_M11_48_s 0.01
R_VDD_M11_48_b VDD VDD_M11_48_b 0.01
M11_48 N004_48_M11_48_d B_48_M11_48_g N006_48_M11_48_s VDD_M11_48_b pmos l=1u w=8u
R_N006_48_M12_48_d N006_48 N006_48_M12_48_d 0.01
R_C_48_M12_48_g C_48 C_48_M12_48_g 0.01
R_N007_48_M12_48_s N007_48 N007_48_M12_48_s 0.01
R_VDD_M12_48_b VDD VDD_M12_48_b 0.01
M12_48 N006_48_M12_48_d C_48_M12_48_g N007_48_M12_48_s VDD_M12_48_b pmos l=1u w=8u
R_N007_48_M13_48_d N007_48 N007_48_M13_48_d 0.01
R_C_48_M13_48_g C_48 C_48_M13_48_g 0.01
R_N008_48_M13_48_s N008_48 N008_48_M13_48_s 0.01
M13_48 N007_48_M13_48_d C_48_M13_48_g N008_48_M13_48_s 0 nmos l=1u w=8u
R_N008_48_M14_48_d N008_48 N008_48_M14_48_d 0.01
R_B_48_M14_48_g B_48 B_48_M14_48_g 0.01
R_N012_48_M14_48_s N012_48 N012_48_M14_48_s 0.01
M14_48 N008_48_M14_48_d B_48_M14_48_g N012_48_M14_48_s 0 nmos l=1u w=8u
R_N012_48_M15_48_d N012_48 N012_48_M15_48_d 0.01
R_A_48_M15_48_g A_48 A_48_M15_48_g 0.01
M15_48 N012_48_M15_48_d A_48_M15_48_g 0 0 nmos l=1u w=8u
R_N010_48_M16_48_d N010_48 N010_48_M16_48_d 0.01
R_C_48_M16_48_g C_48 C_48_M16_48_g 0.01
M16_48 N010_48_M16_48_d C_48_M16_48_g 0 0 nmos l=1u w=2u
R_N010_48_M17_48_d N010_48 N010_48_M17_48_d 0.01
R_B_48_M17_48_g B_48 B_48_M17_48_g 0.01
M17_48 N010_48_M17_48_d B_48_M17_48_g 0 0 nmos l=1u w=2u
R_N010_48_M18_48_d N010_48 N010_48_M18_48_d 0.01
R_A_48_M18_48_g A_48 A_48_M18_48_g 0.01
M18_48 N010_48_M18_48_d A_48_M18_48_g 0 0 nmos l=1u w=2u
R_N007_48_M19_48_d N007_48 N007_48_M19_48_d 0.01
R_N005_48_M19_48_g N005_48 N005_48_M19_48_g 0.01
R_N010_48_M19_48_s N010_48 N010_48_M19_48_s 0.01
M19_48 N007_48_M19_48_d N005_48_M19_48_g N010_48_M19_48_s 0 nmos l=1u w=2u
R_N009_48_M20_48_d N009_48 N009_48_M20_48_d 0.01
R_B_48_M20_48_g B_48 B_48_M20_48_g 0.01
M20_48 N009_48_M20_48_d B_48_M20_48_g 0 0 nmos l=1u w=2u
R_N009_48_M21_48_d N009_48 N009_48_M21_48_d 0.01
R_A_48_M21_48_g A_48 A_48_M21_48_g 0.01
M21_48 N009_48_M21_48_d A_48_M21_48_g 0 0 nmos l=1u w=2u
R_N011_48_M22_48_d N011_48 N011_48_M22_48_d 0.01
R_A_48_M22_48_g A_48 A_48_M22_48_g 0.01
M22_48 N011_48_M22_48_d A_48_M22_48_g 0 0 nmos l=1u w=2u
R_N005_48_M23_48_d N005_48 N005_48_M23_48_d 0.01
R_B_48_M23_48_g B_48 B_48_M23_48_g 0.01
R_N011_48_M23_48_s N011_48 N011_48_M23_48_s 0.01
M23_48 N005_48_M23_48_d B_48_M23_48_g N011_48_M23_48_s 0 nmos l=1u w=2u
R_N005_48_M24_48_d N005_48 N005_48_M24_48_d 0.01
R_C_48_M24_48_g C_48 C_48_M24_48_g 0.01
R_N009_48_M24_48_s N009_48 N009_48_M24_48_s 0.01
M24_48 N005_48_M24_48_d C_48_M24_48_g N009_48_M24_48_s 0 nmos l=1u w=2u
R_C_49_M25_48_d C_49 C_49_M25_48_d 0.01
R_N005_48_M25_48_g N005_48 N005_48_M25_48_g 0.01
M25_48 C_49_M25_48_d N005_48_M25_48_g 0 0 nmos l=1u w=1u
R_N002_48_M26_48_d N002_48 N002_48_M26_48_d 0.01
R_N005_48_M26_48_g N005_48 N005_48_M26_48_g 0.01
R_N007_48_M26_48_s N007_48 N007_48_M26_48_s 0.01
R_VDD_M26_48_b VDD VDD_M26_48_b 0.01
M26_48 N002_48_M26_48_d N005_48_M26_48_g N007_48_M26_48_s VDD_M26_48_b pmos l=1u w=4u
R_VDD_M27_48_d VDD VDD_M27_48_d 0.01
R_N007_48_M27_48_g N007_48 N007_48_M27_48_g 0.01
R_S_48_M27_48_s S_48 S_48_M27_48_s 0.01
R_VDD_M27_48_b VDD VDD_M27_48_b 0.01
M27_48 VDD_M27_48_d N007_48_M27_48_g S_48_M27_48_s VDD_M27_48_b pmos l=1u w=2u
R_S_48_M28_48_d S_48 S_48_M28_48_d 0.01
R_N007_48_M28_48_g N007_48 N007_48_M28_48_g 0.01
M28_48 S_48_M28_48_d N007_48_M28_48_g 0 0 nmos l=1u w=1u
C_S_48 S_48 0 1f
* --- Bit 49 ---
R_VDD_M1_49_d VDD VDD_M1_49_d 0.01
R_A_49_M1_49_g A_49 A_49_M1_49_g 0.01
R_N003_49_M1_49_s N003_49 N003_49_M1_49_s 0.01
R_VDD_M1_49_b VDD VDD_M1_49_b 0.01
M1_49 VDD_M1_49_d A_49_M1_49_g N003_49_M1_49_s VDD_M1_49_b pmos l=1u w=4u
R_N003_49_M2_49_d N003_49 N003_49_M2_49_d 0.01
R_B_49_M2_49_g B_49 B_49_M2_49_g 0.01
R_N005_49_M2_49_s N005_49 N005_49_M2_49_s 0.01
R_VDD_M2_49_b VDD VDD_M2_49_b 0.01
M2_49 N003_49_M2_49_d B_49_M2_49_g N005_49_M2_49_s VDD_M2_49_b pmos l=1u w=4u
R_VDD_M3_49_d VDD VDD_M3_49_d 0.01
R_A_49_M3_49_g A_49 A_49_M3_49_g 0.01
R_N001_49_M3_49_s N001_49 N001_49_M3_49_s 0.01
R_VDD_M3_49_b VDD VDD_M3_49_b 0.01
M3_49 VDD_M3_49_d A_49_M3_49_g N001_49_M3_49_s VDD_M3_49_b pmos l=1u w=4u
R_N001_49_M4_49_d N001_49 N001_49_M4_49_d 0.01
R_C_49_M4_49_g C_49 C_49_M4_49_g 0.01
R_N005_49_M4_49_s N005_49 N005_49_M4_49_s 0.01
R_VDD_M4_49_b VDD VDD_M4_49_b 0.01
M4_49 N001_49_M4_49_d C_49_M4_49_g N005_49_M4_49_s VDD_M4_49_b pmos l=1u w=4u
R_VDD_M5_49_d VDD VDD_M5_49_d 0.01
R_B_49_M5_49_g B_49 B_49_M5_49_g 0.01
R_N001_49_M5_49_s N001_49 N001_49_M5_49_s 0.01
R_VDD_M5_49_b VDD VDD_M5_49_b 0.01
M5_49 VDD_M5_49_d B_49_M5_49_g N001_49_M5_49_s VDD_M5_49_b pmos l=1u w=4u
R_VDD_M6_49_d VDD VDD_M6_49_d 0.01
R_N005_49_M6_49_g N005_49 N005_49_M6_49_g 0.01
R_C_50_M6_49_s C_50 C_50_M6_49_s 0.01
R_VDD_M6_49_b VDD VDD_M6_49_b 0.01
M6_49 VDD_M6_49_d N005_49_M6_49_g C_50_M6_49_s VDD_M6_49_b pmos l=1u w=2u
R_VDD_M7_49_d VDD VDD_M7_49_d 0.01
R_A_49_M7_49_g A_49 A_49_M7_49_g 0.01
R_N002_49_M7_49_s N002_49 N002_49_M7_49_s 0.01
R_VDD_M7_49_b VDD VDD_M7_49_b 0.01
M7_49 VDD_M7_49_d A_49_M7_49_g N002_49_M7_49_s VDD_M7_49_b pmos l=1u w=4u
R_VDD_M8_49_d VDD VDD_M8_49_d 0.01
R_B_49_M8_49_g B_49 B_49_M8_49_g 0.01
R_N002_49_M8_49_s N002_49 N002_49_M8_49_s 0.01
R_VDD_M8_49_b VDD VDD_M8_49_b 0.01
M8_49 VDD_M8_49_d B_49_M8_49_g N002_49_M8_49_s VDD_M8_49_b pmos l=1u w=4u
R_VDD_M9_49_d VDD VDD_M9_49_d 0.01
R_C_49_M9_49_g C_49 C_49_M9_49_g 0.01
R_N002_49_M9_49_s N002_49 N002_49_M9_49_s 0.01
R_VDD_M9_49_b VDD VDD_M9_49_b 0.01
M9_49 VDD_M9_49_d C_49_M9_49_g N002_49_M9_49_s VDD_M9_49_b pmos l=1u w=4u
R_VDD_M10_49_d VDD VDD_M10_49_d 0.01
R_A_49_M10_49_g A_49 A_49_M10_49_g 0.01
R_N004_49_M10_49_s N004_49 N004_49_M10_49_s 0.01
R_VDD_M10_49_b VDD VDD_M10_49_b 0.01
M10_49 VDD_M10_49_d A_49_M10_49_g N004_49_M10_49_s VDD_M10_49_b pmos l=1u w=8u
R_N004_49_M11_49_d N004_49 N004_49_M11_49_d 0.01
R_B_49_M11_49_g B_49 B_49_M11_49_g 0.01
R_N006_49_M11_49_s N006_49 N006_49_M11_49_s 0.01
R_VDD_M11_49_b VDD VDD_M11_49_b 0.01
M11_49 N004_49_M11_49_d B_49_M11_49_g N006_49_M11_49_s VDD_M11_49_b pmos l=1u w=8u
R_N006_49_M12_49_d N006_49 N006_49_M12_49_d 0.01
R_C_49_M12_49_g C_49 C_49_M12_49_g 0.01
R_N007_49_M12_49_s N007_49 N007_49_M12_49_s 0.01
R_VDD_M12_49_b VDD VDD_M12_49_b 0.01
M12_49 N006_49_M12_49_d C_49_M12_49_g N007_49_M12_49_s VDD_M12_49_b pmos l=1u w=8u
R_N007_49_M13_49_d N007_49 N007_49_M13_49_d 0.01
R_C_49_M13_49_g C_49 C_49_M13_49_g 0.01
R_N008_49_M13_49_s N008_49 N008_49_M13_49_s 0.01
M13_49 N007_49_M13_49_d C_49_M13_49_g N008_49_M13_49_s 0 nmos l=1u w=8u
R_N008_49_M14_49_d N008_49 N008_49_M14_49_d 0.01
R_B_49_M14_49_g B_49 B_49_M14_49_g 0.01
R_N012_49_M14_49_s N012_49 N012_49_M14_49_s 0.01
M14_49 N008_49_M14_49_d B_49_M14_49_g N012_49_M14_49_s 0 nmos l=1u w=8u
R_N012_49_M15_49_d N012_49 N012_49_M15_49_d 0.01
R_A_49_M15_49_g A_49 A_49_M15_49_g 0.01
M15_49 N012_49_M15_49_d A_49_M15_49_g 0 0 nmos l=1u w=8u
R_N010_49_M16_49_d N010_49 N010_49_M16_49_d 0.01
R_C_49_M16_49_g C_49 C_49_M16_49_g 0.01
M16_49 N010_49_M16_49_d C_49_M16_49_g 0 0 nmos l=1u w=2u
R_N010_49_M17_49_d N010_49 N010_49_M17_49_d 0.01
R_B_49_M17_49_g B_49 B_49_M17_49_g 0.01
M17_49 N010_49_M17_49_d B_49_M17_49_g 0 0 nmos l=1u w=2u
R_N010_49_M18_49_d N010_49 N010_49_M18_49_d 0.01
R_A_49_M18_49_g A_49 A_49_M18_49_g 0.01
M18_49 N010_49_M18_49_d A_49_M18_49_g 0 0 nmos l=1u w=2u
R_N007_49_M19_49_d N007_49 N007_49_M19_49_d 0.01
R_N005_49_M19_49_g N005_49 N005_49_M19_49_g 0.01
R_N010_49_M19_49_s N010_49 N010_49_M19_49_s 0.01
M19_49 N007_49_M19_49_d N005_49_M19_49_g N010_49_M19_49_s 0 nmos l=1u w=2u
R_N009_49_M20_49_d N009_49 N009_49_M20_49_d 0.01
R_B_49_M20_49_g B_49 B_49_M20_49_g 0.01
M20_49 N009_49_M20_49_d B_49_M20_49_g 0 0 nmos l=1u w=2u
R_N009_49_M21_49_d N009_49 N009_49_M21_49_d 0.01
R_A_49_M21_49_g A_49 A_49_M21_49_g 0.01
M21_49 N009_49_M21_49_d A_49_M21_49_g 0 0 nmos l=1u w=2u
R_N011_49_M22_49_d N011_49 N011_49_M22_49_d 0.01
R_A_49_M22_49_g A_49 A_49_M22_49_g 0.01
M22_49 N011_49_M22_49_d A_49_M22_49_g 0 0 nmos l=1u w=2u
R_N005_49_M23_49_d N005_49 N005_49_M23_49_d 0.01
R_B_49_M23_49_g B_49 B_49_M23_49_g 0.01
R_N011_49_M23_49_s N011_49 N011_49_M23_49_s 0.01
M23_49 N005_49_M23_49_d B_49_M23_49_g N011_49_M23_49_s 0 nmos l=1u w=2u
R_N005_49_M24_49_d N005_49 N005_49_M24_49_d 0.01
R_C_49_M24_49_g C_49 C_49_M24_49_g 0.01
R_N009_49_M24_49_s N009_49 N009_49_M24_49_s 0.01
M24_49 N005_49_M24_49_d C_49_M24_49_g N009_49_M24_49_s 0 nmos l=1u w=2u
R_C_50_M25_49_d C_50 C_50_M25_49_d 0.01
R_N005_49_M25_49_g N005_49 N005_49_M25_49_g 0.01
M25_49 C_50_M25_49_d N005_49_M25_49_g 0 0 nmos l=1u w=1u
R_N002_49_M26_49_d N002_49 N002_49_M26_49_d 0.01
R_N005_49_M26_49_g N005_49 N005_49_M26_49_g 0.01
R_N007_49_M26_49_s N007_49 N007_49_M26_49_s 0.01
R_VDD_M26_49_b VDD VDD_M26_49_b 0.01
M26_49 N002_49_M26_49_d N005_49_M26_49_g N007_49_M26_49_s VDD_M26_49_b pmos l=1u w=4u
R_VDD_M27_49_d VDD VDD_M27_49_d 0.01
R_N007_49_M27_49_g N007_49 N007_49_M27_49_g 0.01
R_S_49_M27_49_s S_49 S_49_M27_49_s 0.01
R_VDD_M27_49_b VDD VDD_M27_49_b 0.01
M27_49 VDD_M27_49_d N007_49_M27_49_g S_49_M27_49_s VDD_M27_49_b pmos l=1u w=2u
R_S_49_M28_49_d S_49 S_49_M28_49_d 0.01
R_N007_49_M28_49_g N007_49 N007_49_M28_49_g 0.01
M28_49 S_49_M28_49_d N007_49_M28_49_g 0 0 nmos l=1u w=1u
C_S_49 S_49 0 1f
* --- Bit 50 ---
R_VDD_M1_50_d VDD VDD_M1_50_d 0.01
R_A_50_M1_50_g A_50 A_50_M1_50_g 0.01
R_N003_50_M1_50_s N003_50 N003_50_M1_50_s 0.01
R_VDD_M1_50_b VDD VDD_M1_50_b 0.01
M1_50 VDD_M1_50_d A_50_M1_50_g N003_50_M1_50_s VDD_M1_50_b pmos l=1u w=4u
R_N003_50_M2_50_d N003_50 N003_50_M2_50_d 0.01
R_B_50_M2_50_g B_50 B_50_M2_50_g 0.01
R_N005_50_M2_50_s N005_50 N005_50_M2_50_s 0.01
R_VDD_M2_50_b VDD VDD_M2_50_b 0.01
M2_50 N003_50_M2_50_d B_50_M2_50_g N005_50_M2_50_s VDD_M2_50_b pmos l=1u w=4u
R_VDD_M3_50_d VDD VDD_M3_50_d 0.01
R_A_50_M3_50_g A_50 A_50_M3_50_g 0.01
R_N001_50_M3_50_s N001_50 N001_50_M3_50_s 0.01
R_VDD_M3_50_b VDD VDD_M3_50_b 0.01
M3_50 VDD_M3_50_d A_50_M3_50_g N001_50_M3_50_s VDD_M3_50_b pmos l=1u w=4u
R_N001_50_M4_50_d N001_50 N001_50_M4_50_d 0.01
R_C_50_M4_50_g C_50 C_50_M4_50_g 0.01
R_N005_50_M4_50_s N005_50 N005_50_M4_50_s 0.01
R_VDD_M4_50_b VDD VDD_M4_50_b 0.01
M4_50 N001_50_M4_50_d C_50_M4_50_g N005_50_M4_50_s VDD_M4_50_b pmos l=1u w=4u
R_VDD_M5_50_d VDD VDD_M5_50_d 0.01
R_B_50_M5_50_g B_50 B_50_M5_50_g 0.01
R_N001_50_M5_50_s N001_50 N001_50_M5_50_s 0.01
R_VDD_M5_50_b VDD VDD_M5_50_b 0.01
M5_50 VDD_M5_50_d B_50_M5_50_g N001_50_M5_50_s VDD_M5_50_b pmos l=1u w=4u
R_VDD_M6_50_d VDD VDD_M6_50_d 0.01
R_N005_50_M6_50_g N005_50 N005_50_M6_50_g 0.01
R_C_51_M6_50_s C_51 C_51_M6_50_s 0.01
R_VDD_M6_50_b VDD VDD_M6_50_b 0.01
M6_50 VDD_M6_50_d N005_50_M6_50_g C_51_M6_50_s VDD_M6_50_b pmos l=1u w=2u
R_VDD_M7_50_d VDD VDD_M7_50_d 0.01
R_A_50_M7_50_g A_50 A_50_M7_50_g 0.01
R_N002_50_M7_50_s N002_50 N002_50_M7_50_s 0.01
R_VDD_M7_50_b VDD VDD_M7_50_b 0.01
M7_50 VDD_M7_50_d A_50_M7_50_g N002_50_M7_50_s VDD_M7_50_b pmos l=1u w=4u
R_VDD_M8_50_d VDD VDD_M8_50_d 0.01
R_B_50_M8_50_g B_50 B_50_M8_50_g 0.01
R_N002_50_M8_50_s N002_50 N002_50_M8_50_s 0.01
R_VDD_M8_50_b VDD VDD_M8_50_b 0.01
M8_50 VDD_M8_50_d B_50_M8_50_g N002_50_M8_50_s VDD_M8_50_b pmos l=1u w=4u
R_VDD_M9_50_d VDD VDD_M9_50_d 0.01
R_C_50_M9_50_g C_50 C_50_M9_50_g 0.01
R_N002_50_M9_50_s N002_50 N002_50_M9_50_s 0.01
R_VDD_M9_50_b VDD VDD_M9_50_b 0.01
M9_50 VDD_M9_50_d C_50_M9_50_g N002_50_M9_50_s VDD_M9_50_b pmos l=1u w=4u
R_VDD_M10_50_d VDD VDD_M10_50_d 0.01
R_A_50_M10_50_g A_50 A_50_M10_50_g 0.01
R_N004_50_M10_50_s N004_50 N004_50_M10_50_s 0.01
R_VDD_M10_50_b VDD VDD_M10_50_b 0.01
M10_50 VDD_M10_50_d A_50_M10_50_g N004_50_M10_50_s VDD_M10_50_b pmos l=1u w=8u
R_N004_50_M11_50_d N004_50 N004_50_M11_50_d 0.01
R_B_50_M11_50_g B_50 B_50_M11_50_g 0.01
R_N006_50_M11_50_s N006_50 N006_50_M11_50_s 0.01
R_VDD_M11_50_b VDD VDD_M11_50_b 0.01
M11_50 N004_50_M11_50_d B_50_M11_50_g N006_50_M11_50_s VDD_M11_50_b pmos l=1u w=8u
R_N006_50_M12_50_d N006_50 N006_50_M12_50_d 0.01
R_C_50_M12_50_g C_50 C_50_M12_50_g 0.01
R_N007_50_M12_50_s N007_50 N007_50_M12_50_s 0.01
R_VDD_M12_50_b VDD VDD_M12_50_b 0.01
M12_50 N006_50_M12_50_d C_50_M12_50_g N007_50_M12_50_s VDD_M12_50_b pmos l=1u w=8u
R_N007_50_M13_50_d N007_50 N007_50_M13_50_d 0.01
R_C_50_M13_50_g C_50 C_50_M13_50_g 0.01
R_N008_50_M13_50_s N008_50 N008_50_M13_50_s 0.01
M13_50 N007_50_M13_50_d C_50_M13_50_g N008_50_M13_50_s 0 nmos l=1u w=8u
R_N008_50_M14_50_d N008_50 N008_50_M14_50_d 0.01
R_B_50_M14_50_g B_50 B_50_M14_50_g 0.01
R_N012_50_M14_50_s N012_50 N012_50_M14_50_s 0.01
M14_50 N008_50_M14_50_d B_50_M14_50_g N012_50_M14_50_s 0 nmos l=1u w=8u
R_N012_50_M15_50_d N012_50 N012_50_M15_50_d 0.01
R_A_50_M15_50_g A_50 A_50_M15_50_g 0.01
M15_50 N012_50_M15_50_d A_50_M15_50_g 0 0 nmos l=1u w=8u
R_N010_50_M16_50_d N010_50 N010_50_M16_50_d 0.01
R_C_50_M16_50_g C_50 C_50_M16_50_g 0.01
M16_50 N010_50_M16_50_d C_50_M16_50_g 0 0 nmos l=1u w=2u
R_N010_50_M17_50_d N010_50 N010_50_M17_50_d 0.01
R_B_50_M17_50_g B_50 B_50_M17_50_g 0.01
M17_50 N010_50_M17_50_d B_50_M17_50_g 0 0 nmos l=1u w=2u
R_N010_50_M18_50_d N010_50 N010_50_M18_50_d 0.01
R_A_50_M18_50_g A_50 A_50_M18_50_g 0.01
M18_50 N010_50_M18_50_d A_50_M18_50_g 0 0 nmos l=1u w=2u
R_N007_50_M19_50_d N007_50 N007_50_M19_50_d 0.01
R_N005_50_M19_50_g N005_50 N005_50_M19_50_g 0.01
R_N010_50_M19_50_s N010_50 N010_50_M19_50_s 0.01
M19_50 N007_50_M19_50_d N005_50_M19_50_g N010_50_M19_50_s 0 nmos l=1u w=2u
R_N009_50_M20_50_d N009_50 N009_50_M20_50_d 0.01
R_B_50_M20_50_g B_50 B_50_M20_50_g 0.01
M20_50 N009_50_M20_50_d B_50_M20_50_g 0 0 nmos l=1u w=2u
R_N009_50_M21_50_d N009_50 N009_50_M21_50_d 0.01
R_A_50_M21_50_g A_50 A_50_M21_50_g 0.01
M21_50 N009_50_M21_50_d A_50_M21_50_g 0 0 nmos l=1u w=2u
R_N011_50_M22_50_d N011_50 N011_50_M22_50_d 0.01
R_A_50_M22_50_g A_50 A_50_M22_50_g 0.01
M22_50 N011_50_M22_50_d A_50_M22_50_g 0 0 nmos l=1u w=2u
R_N005_50_M23_50_d N005_50 N005_50_M23_50_d 0.01
R_B_50_M23_50_g B_50 B_50_M23_50_g 0.01
R_N011_50_M23_50_s N011_50 N011_50_M23_50_s 0.01
M23_50 N005_50_M23_50_d B_50_M23_50_g N011_50_M23_50_s 0 nmos l=1u w=2u
R_N005_50_M24_50_d N005_50 N005_50_M24_50_d 0.01
R_C_50_M24_50_g C_50 C_50_M24_50_g 0.01
R_N009_50_M24_50_s N009_50 N009_50_M24_50_s 0.01
M24_50 N005_50_M24_50_d C_50_M24_50_g N009_50_M24_50_s 0 nmos l=1u w=2u
R_C_51_M25_50_d C_51 C_51_M25_50_d 0.01
R_N005_50_M25_50_g N005_50 N005_50_M25_50_g 0.01
M25_50 C_51_M25_50_d N005_50_M25_50_g 0 0 nmos l=1u w=1u
R_N002_50_M26_50_d N002_50 N002_50_M26_50_d 0.01
R_N005_50_M26_50_g N005_50 N005_50_M26_50_g 0.01
R_N007_50_M26_50_s N007_50 N007_50_M26_50_s 0.01
R_VDD_M26_50_b VDD VDD_M26_50_b 0.01
M26_50 N002_50_M26_50_d N005_50_M26_50_g N007_50_M26_50_s VDD_M26_50_b pmos l=1u w=4u
R_VDD_M27_50_d VDD VDD_M27_50_d 0.01
R_N007_50_M27_50_g N007_50 N007_50_M27_50_g 0.01
R_S_50_M27_50_s S_50 S_50_M27_50_s 0.01
R_VDD_M27_50_b VDD VDD_M27_50_b 0.01
M27_50 VDD_M27_50_d N007_50_M27_50_g S_50_M27_50_s VDD_M27_50_b pmos l=1u w=2u
R_S_50_M28_50_d S_50 S_50_M28_50_d 0.01
R_N007_50_M28_50_g N007_50 N007_50_M28_50_g 0.01
M28_50 S_50_M28_50_d N007_50_M28_50_g 0 0 nmos l=1u w=1u
C_S_50 S_50 0 1f
* --- Bit 51 ---
R_VDD_M1_51_d VDD VDD_M1_51_d 0.01
R_A_51_M1_51_g A_51 A_51_M1_51_g 0.01
R_N003_51_M1_51_s N003_51 N003_51_M1_51_s 0.01
R_VDD_M1_51_b VDD VDD_M1_51_b 0.01
M1_51 VDD_M1_51_d A_51_M1_51_g N003_51_M1_51_s VDD_M1_51_b pmos l=1u w=4u
R_N003_51_M2_51_d N003_51 N003_51_M2_51_d 0.01
R_B_51_M2_51_g B_51 B_51_M2_51_g 0.01
R_N005_51_M2_51_s N005_51 N005_51_M2_51_s 0.01
R_VDD_M2_51_b VDD VDD_M2_51_b 0.01
M2_51 N003_51_M2_51_d B_51_M2_51_g N005_51_M2_51_s VDD_M2_51_b pmos l=1u w=4u
R_VDD_M3_51_d VDD VDD_M3_51_d 0.01
R_A_51_M3_51_g A_51 A_51_M3_51_g 0.01
R_N001_51_M3_51_s N001_51 N001_51_M3_51_s 0.01
R_VDD_M3_51_b VDD VDD_M3_51_b 0.01
M3_51 VDD_M3_51_d A_51_M3_51_g N001_51_M3_51_s VDD_M3_51_b pmos l=1u w=4u
R_N001_51_M4_51_d N001_51 N001_51_M4_51_d 0.01
R_C_51_M4_51_g C_51 C_51_M4_51_g 0.01
R_N005_51_M4_51_s N005_51 N005_51_M4_51_s 0.01
R_VDD_M4_51_b VDD VDD_M4_51_b 0.01
M4_51 N001_51_M4_51_d C_51_M4_51_g N005_51_M4_51_s VDD_M4_51_b pmos l=1u w=4u
R_VDD_M5_51_d VDD VDD_M5_51_d 0.01
R_B_51_M5_51_g B_51 B_51_M5_51_g 0.01
R_N001_51_M5_51_s N001_51 N001_51_M5_51_s 0.01
R_VDD_M5_51_b VDD VDD_M5_51_b 0.01
M5_51 VDD_M5_51_d B_51_M5_51_g N001_51_M5_51_s VDD_M5_51_b pmos l=1u w=4u
R_VDD_M6_51_d VDD VDD_M6_51_d 0.01
R_N005_51_M6_51_g N005_51 N005_51_M6_51_g 0.01
R_C_52_M6_51_s C_52 C_52_M6_51_s 0.01
R_VDD_M6_51_b VDD VDD_M6_51_b 0.01
M6_51 VDD_M6_51_d N005_51_M6_51_g C_52_M6_51_s VDD_M6_51_b pmos l=1u w=2u
R_VDD_M7_51_d VDD VDD_M7_51_d 0.01
R_A_51_M7_51_g A_51 A_51_M7_51_g 0.01
R_N002_51_M7_51_s N002_51 N002_51_M7_51_s 0.01
R_VDD_M7_51_b VDD VDD_M7_51_b 0.01
M7_51 VDD_M7_51_d A_51_M7_51_g N002_51_M7_51_s VDD_M7_51_b pmos l=1u w=4u
R_VDD_M8_51_d VDD VDD_M8_51_d 0.01
R_B_51_M8_51_g B_51 B_51_M8_51_g 0.01
R_N002_51_M8_51_s N002_51 N002_51_M8_51_s 0.01
R_VDD_M8_51_b VDD VDD_M8_51_b 0.01
M8_51 VDD_M8_51_d B_51_M8_51_g N002_51_M8_51_s VDD_M8_51_b pmos l=1u w=4u
R_VDD_M9_51_d VDD VDD_M9_51_d 0.01
R_C_51_M9_51_g C_51 C_51_M9_51_g 0.01
R_N002_51_M9_51_s N002_51 N002_51_M9_51_s 0.01
R_VDD_M9_51_b VDD VDD_M9_51_b 0.01
M9_51 VDD_M9_51_d C_51_M9_51_g N002_51_M9_51_s VDD_M9_51_b pmos l=1u w=4u
R_VDD_M10_51_d VDD VDD_M10_51_d 0.01
R_A_51_M10_51_g A_51 A_51_M10_51_g 0.01
R_N004_51_M10_51_s N004_51 N004_51_M10_51_s 0.01
R_VDD_M10_51_b VDD VDD_M10_51_b 0.01
M10_51 VDD_M10_51_d A_51_M10_51_g N004_51_M10_51_s VDD_M10_51_b pmos l=1u w=8u
R_N004_51_M11_51_d N004_51 N004_51_M11_51_d 0.01
R_B_51_M11_51_g B_51 B_51_M11_51_g 0.01
R_N006_51_M11_51_s N006_51 N006_51_M11_51_s 0.01
R_VDD_M11_51_b VDD VDD_M11_51_b 0.01
M11_51 N004_51_M11_51_d B_51_M11_51_g N006_51_M11_51_s VDD_M11_51_b pmos l=1u w=8u
R_N006_51_M12_51_d N006_51 N006_51_M12_51_d 0.01
R_C_51_M12_51_g C_51 C_51_M12_51_g 0.01
R_N007_51_M12_51_s N007_51 N007_51_M12_51_s 0.01
R_VDD_M12_51_b VDD VDD_M12_51_b 0.01
M12_51 N006_51_M12_51_d C_51_M12_51_g N007_51_M12_51_s VDD_M12_51_b pmos l=1u w=8u
R_N007_51_M13_51_d N007_51 N007_51_M13_51_d 0.01
R_C_51_M13_51_g C_51 C_51_M13_51_g 0.01
R_N008_51_M13_51_s N008_51 N008_51_M13_51_s 0.01
M13_51 N007_51_M13_51_d C_51_M13_51_g N008_51_M13_51_s 0 nmos l=1u w=8u
R_N008_51_M14_51_d N008_51 N008_51_M14_51_d 0.01
R_B_51_M14_51_g B_51 B_51_M14_51_g 0.01
R_N012_51_M14_51_s N012_51 N012_51_M14_51_s 0.01
M14_51 N008_51_M14_51_d B_51_M14_51_g N012_51_M14_51_s 0 nmos l=1u w=8u
R_N012_51_M15_51_d N012_51 N012_51_M15_51_d 0.01
R_A_51_M15_51_g A_51 A_51_M15_51_g 0.01
M15_51 N012_51_M15_51_d A_51_M15_51_g 0 0 nmos l=1u w=8u
R_N010_51_M16_51_d N010_51 N010_51_M16_51_d 0.01
R_C_51_M16_51_g C_51 C_51_M16_51_g 0.01
M16_51 N010_51_M16_51_d C_51_M16_51_g 0 0 nmos l=1u w=2u
R_N010_51_M17_51_d N010_51 N010_51_M17_51_d 0.01
R_B_51_M17_51_g B_51 B_51_M17_51_g 0.01
M17_51 N010_51_M17_51_d B_51_M17_51_g 0 0 nmos l=1u w=2u
R_N010_51_M18_51_d N010_51 N010_51_M18_51_d 0.01
R_A_51_M18_51_g A_51 A_51_M18_51_g 0.01
M18_51 N010_51_M18_51_d A_51_M18_51_g 0 0 nmos l=1u w=2u
R_N007_51_M19_51_d N007_51 N007_51_M19_51_d 0.01
R_N005_51_M19_51_g N005_51 N005_51_M19_51_g 0.01
R_N010_51_M19_51_s N010_51 N010_51_M19_51_s 0.01
M19_51 N007_51_M19_51_d N005_51_M19_51_g N010_51_M19_51_s 0 nmos l=1u w=2u
R_N009_51_M20_51_d N009_51 N009_51_M20_51_d 0.01
R_B_51_M20_51_g B_51 B_51_M20_51_g 0.01
M20_51 N009_51_M20_51_d B_51_M20_51_g 0 0 nmos l=1u w=2u
R_N009_51_M21_51_d N009_51 N009_51_M21_51_d 0.01
R_A_51_M21_51_g A_51 A_51_M21_51_g 0.01
M21_51 N009_51_M21_51_d A_51_M21_51_g 0 0 nmos l=1u w=2u
R_N011_51_M22_51_d N011_51 N011_51_M22_51_d 0.01
R_A_51_M22_51_g A_51 A_51_M22_51_g 0.01
M22_51 N011_51_M22_51_d A_51_M22_51_g 0 0 nmos l=1u w=2u
R_N005_51_M23_51_d N005_51 N005_51_M23_51_d 0.01
R_B_51_M23_51_g B_51 B_51_M23_51_g 0.01
R_N011_51_M23_51_s N011_51 N011_51_M23_51_s 0.01
M23_51 N005_51_M23_51_d B_51_M23_51_g N011_51_M23_51_s 0 nmos l=1u w=2u
R_N005_51_M24_51_d N005_51 N005_51_M24_51_d 0.01
R_C_51_M24_51_g C_51 C_51_M24_51_g 0.01
R_N009_51_M24_51_s N009_51 N009_51_M24_51_s 0.01
M24_51 N005_51_M24_51_d C_51_M24_51_g N009_51_M24_51_s 0 nmos l=1u w=2u
R_C_52_M25_51_d C_52 C_52_M25_51_d 0.01
R_N005_51_M25_51_g N005_51 N005_51_M25_51_g 0.01
M25_51 C_52_M25_51_d N005_51_M25_51_g 0 0 nmos l=1u w=1u
R_N002_51_M26_51_d N002_51 N002_51_M26_51_d 0.01
R_N005_51_M26_51_g N005_51 N005_51_M26_51_g 0.01
R_N007_51_M26_51_s N007_51 N007_51_M26_51_s 0.01
R_VDD_M26_51_b VDD VDD_M26_51_b 0.01
M26_51 N002_51_M26_51_d N005_51_M26_51_g N007_51_M26_51_s VDD_M26_51_b pmos l=1u w=4u
R_VDD_M27_51_d VDD VDD_M27_51_d 0.01
R_N007_51_M27_51_g N007_51 N007_51_M27_51_g 0.01
R_S_51_M27_51_s S_51 S_51_M27_51_s 0.01
R_VDD_M27_51_b VDD VDD_M27_51_b 0.01
M27_51 VDD_M27_51_d N007_51_M27_51_g S_51_M27_51_s VDD_M27_51_b pmos l=1u w=2u
R_S_51_M28_51_d S_51 S_51_M28_51_d 0.01
R_N007_51_M28_51_g N007_51 N007_51_M28_51_g 0.01
M28_51 S_51_M28_51_d N007_51_M28_51_g 0 0 nmos l=1u w=1u
C_S_51 S_51 0 1f
* --- Bit 52 ---
R_VDD_M1_52_d VDD VDD_M1_52_d 0.01
R_A_52_M1_52_g A_52 A_52_M1_52_g 0.01
R_N003_52_M1_52_s N003_52 N003_52_M1_52_s 0.01
R_VDD_M1_52_b VDD VDD_M1_52_b 0.01
M1_52 VDD_M1_52_d A_52_M1_52_g N003_52_M1_52_s VDD_M1_52_b pmos l=1u w=4u
R_N003_52_M2_52_d N003_52 N003_52_M2_52_d 0.01
R_B_52_M2_52_g B_52 B_52_M2_52_g 0.01
R_N005_52_M2_52_s N005_52 N005_52_M2_52_s 0.01
R_VDD_M2_52_b VDD VDD_M2_52_b 0.01
M2_52 N003_52_M2_52_d B_52_M2_52_g N005_52_M2_52_s VDD_M2_52_b pmos l=1u w=4u
R_VDD_M3_52_d VDD VDD_M3_52_d 0.01
R_A_52_M3_52_g A_52 A_52_M3_52_g 0.01
R_N001_52_M3_52_s N001_52 N001_52_M3_52_s 0.01
R_VDD_M3_52_b VDD VDD_M3_52_b 0.01
M3_52 VDD_M3_52_d A_52_M3_52_g N001_52_M3_52_s VDD_M3_52_b pmos l=1u w=4u
R_N001_52_M4_52_d N001_52 N001_52_M4_52_d 0.01
R_C_52_M4_52_g C_52 C_52_M4_52_g 0.01
R_N005_52_M4_52_s N005_52 N005_52_M4_52_s 0.01
R_VDD_M4_52_b VDD VDD_M4_52_b 0.01
M4_52 N001_52_M4_52_d C_52_M4_52_g N005_52_M4_52_s VDD_M4_52_b pmos l=1u w=4u
R_VDD_M5_52_d VDD VDD_M5_52_d 0.01
R_B_52_M5_52_g B_52 B_52_M5_52_g 0.01
R_N001_52_M5_52_s N001_52 N001_52_M5_52_s 0.01
R_VDD_M5_52_b VDD VDD_M5_52_b 0.01
M5_52 VDD_M5_52_d B_52_M5_52_g N001_52_M5_52_s VDD_M5_52_b pmos l=1u w=4u
R_VDD_M6_52_d VDD VDD_M6_52_d 0.01
R_N005_52_M6_52_g N005_52 N005_52_M6_52_g 0.01
R_C_53_M6_52_s C_53 C_53_M6_52_s 0.01
R_VDD_M6_52_b VDD VDD_M6_52_b 0.01
M6_52 VDD_M6_52_d N005_52_M6_52_g C_53_M6_52_s VDD_M6_52_b pmos l=1u w=2u
R_VDD_M7_52_d VDD VDD_M7_52_d 0.01
R_A_52_M7_52_g A_52 A_52_M7_52_g 0.01
R_N002_52_M7_52_s N002_52 N002_52_M7_52_s 0.01
R_VDD_M7_52_b VDD VDD_M7_52_b 0.01
M7_52 VDD_M7_52_d A_52_M7_52_g N002_52_M7_52_s VDD_M7_52_b pmos l=1u w=4u
R_VDD_M8_52_d VDD VDD_M8_52_d 0.01
R_B_52_M8_52_g B_52 B_52_M8_52_g 0.01
R_N002_52_M8_52_s N002_52 N002_52_M8_52_s 0.01
R_VDD_M8_52_b VDD VDD_M8_52_b 0.01
M8_52 VDD_M8_52_d B_52_M8_52_g N002_52_M8_52_s VDD_M8_52_b pmos l=1u w=4u
R_VDD_M9_52_d VDD VDD_M9_52_d 0.01
R_C_52_M9_52_g C_52 C_52_M9_52_g 0.01
R_N002_52_M9_52_s N002_52 N002_52_M9_52_s 0.01
R_VDD_M9_52_b VDD VDD_M9_52_b 0.01
M9_52 VDD_M9_52_d C_52_M9_52_g N002_52_M9_52_s VDD_M9_52_b pmos l=1u w=4u
R_VDD_M10_52_d VDD VDD_M10_52_d 0.01
R_A_52_M10_52_g A_52 A_52_M10_52_g 0.01
R_N004_52_M10_52_s N004_52 N004_52_M10_52_s 0.01
R_VDD_M10_52_b VDD VDD_M10_52_b 0.01
M10_52 VDD_M10_52_d A_52_M10_52_g N004_52_M10_52_s VDD_M10_52_b pmos l=1u w=8u
R_N004_52_M11_52_d N004_52 N004_52_M11_52_d 0.01
R_B_52_M11_52_g B_52 B_52_M11_52_g 0.01
R_N006_52_M11_52_s N006_52 N006_52_M11_52_s 0.01
R_VDD_M11_52_b VDD VDD_M11_52_b 0.01
M11_52 N004_52_M11_52_d B_52_M11_52_g N006_52_M11_52_s VDD_M11_52_b pmos l=1u w=8u
R_N006_52_M12_52_d N006_52 N006_52_M12_52_d 0.01
R_C_52_M12_52_g C_52 C_52_M12_52_g 0.01
R_N007_52_M12_52_s N007_52 N007_52_M12_52_s 0.01
R_VDD_M12_52_b VDD VDD_M12_52_b 0.01
M12_52 N006_52_M12_52_d C_52_M12_52_g N007_52_M12_52_s VDD_M12_52_b pmos l=1u w=8u
R_N007_52_M13_52_d N007_52 N007_52_M13_52_d 0.01
R_C_52_M13_52_g C_52 C_52_M13_52_g 0.01
R_N008_52_M13_52_s N008_52 N008_52_M13_52_s 0.01
M13_52 N007_52_M13_52_d C_52_M13_52_g N008_52_M13_52_s 0 nmos l=1u w=8u
R_N008_52_M14_52_d N008_52 N008_52_M14_52_d 0.01
R_B_52_M14_52_g B_52 B_52_M14_52_g 0.01
R_N012_52_M14_52_s N012_52 N012_52_M14_52_s 0.01
M14_52 N008_52_M14_52_d B_52_M14_52_g N012_52_M14_52_s 0 nmos l=1u w=8u
R_N012_52_M15_52_d N012_52 N012_52_M15_52_d 0.01
R_A_52_M15_52_g A_52 A_52_M15_52_g 0.01
M15_52 N012_52_M15_52_d A_52_M15_52_g 0 0 nmos l=1u w=8u
R_N010_52_M16_52_d N010_52 N010_52_M16_52_d 0.01
R_C_52_M16_52_g C_52 C_52_M16_52_g 0.01
M16_52 N010_52_M16_52_d C_52_M16_52_g 0 0 nmos l=1u w=2u
R_N010_52_M17_52_d N010_52 N010_52_M17_52_d 0.01
R_B_52_M17_52_g B_52 B_52_M17_52_g 0.01
M17_52 N010_52_M17_52_d B_52_M17_52_g 0 0 nmos l=1u w=2u
R_N010_52_M18_52_d N010_52 N010_52_M18_52_d 0.01
R_A_52_M18_52_g A_52 A_52_M18_52_g 0.01
M18_52 N010_52_M18_52_d A_52_M18_52_g 0 0 nmos l=1u w=2u
R_N007_52_M19_52_d N007_52 N007_52_M19_52_d 0.01
R_N005_52_M19_52_g N005_52 N005_52_M19_52_g 0.01
R_N010_52_M19_52_s N010_52 N010_52_M19_52_s 0.01
M19_52 N007_52_M19_52_d N005_52_M19_52_g N010_52_M19_52_s 0 nmos l=1u w=2u
R_N009_52_M20_52_d N009_52 N009_52_M20_52_d 0.01
R_B_52_M20_52_g B_52 B_52_M20_52_g 0.01
M20_52 N009_52_M20_52_d B_52_M20_52_g 0 0 nmos l=1u w=2u
R_N009_52_M21_52_d N009_52 N009_52_M21_52_d 0.01
R_A_52_M21_52_g A_52 A_52_M21_52_g 0.01
M21_52 N009_52_M21_52_d A_52_M21_52_g 0 0 nmos l=1u w=2u
R_N011_52_M22_52_d N011_52 N011_52_M22_52_d 0.01
R_A_52_M22_52_g A_52 A_52_M22_52_g 0.01
M22_52 N011_52_M22_52_d A_52_M22_52_g 0 0 nmos l=1u w=2u
R_N005_52_M23_52_d N005_52 N005_52_M23_52_d 0.01
R_B_52_M23_52_g B_52 B_52_M23_52_g 0.01
R_N011_52_M23_52_s N011_52 N011_52_M23_52_s 0.01
M23_52 N005_52_M23_52_d B_52_M23_52_g N011_52_M23_52_s 0 nmos l=1u w=2u
R_N005_52_M24_52_d N005_52 N005_52_M24_52_d 0.01
R_C_52_M24_52_g C_52 C_52_M24_52_g 0.01
R_N009_52_M24_52_s N009_52 N009_52_M24_52_s 0.01
M24_52 N005_52_M24_52_d C_52_M24_52_g N009_52_M24_52_s 0 nmos l=1u w=2u
R_C_53_M25_52_d C_53 C_53_M25_52_d 0.01
R_N005_52_M25_52_g N005_52 N005_52_M25_52_g 0.01
M25_52 C_53_M25_52_d N005_52_M25_52_g 0 0 nmos l=1u w=1u
R_N002_52_M26_52_d N002_52 N002_52_M26_52_d 0.01
R_N005_52_M26_52_g N005_52 N005_52_M26_52_g 0.01
R_N007_52_M26_52_s N007_52 N007_52_M26_52_s 0.01
R_VDD_M26_52_b VDD VDD_M26_52_b 0.01
M26_52 N002_52_M26_52_d N005_52_M26_52_g N007_52_M26_52_s VDD_M26_52_b pmos l=1u w=4u
R_VDD_M27_52_d VDD VDD_M27_52_d 0.01
R_N007_52_M27_52_g N007_52 N007_52_M27_52_g 0.01
R_S_52_M27_52_s S_52 S_52_M27_52_s 0.01
R_VDD_M27_52_b VDD VDD_M27_52_b 0.01
M27_52 VDD_M27_52_d N007_52_M27_52_g S_52_M27_52_s VDD_M27_52_b pmos l=1u w=2u
R_S_52_M28_52_d S_52 S_52_M28_52_d 0.01
R_N007_52_M28_52_g N007_52 N007_52_M28_52_g 0.01
M28_52 S_52_M28_52_d N007_52_M28_52_g 0 0 nmos l=1u w=1u
C_S_52 S_52 0 1f
* --- Bit 53 ---
R_VDD_M1_53_d VDD VDD_M1_53_d 0.01
R_A_53_M1_53_g A_53 A_53_M1_53_g 0.01
R_N003_53_M1_53_s N003_53 N003_53_M1_53_s 0.01
R_VDD_M1_53_b VDD VDD_M1_53_b 0.01
M1_53 VDD_M1_53_d A_53_M1_53_g N003_53_M1_53_s VDD_M1_53_b pmos l=1u w=4u
R_N003_53_M2_53_d N003_53 N003_53_M2_53_d 0.01
R_B_53_M2_53_g B_53 B_53_M2_53_g 0.01
R_N005_53_M2_53_s N005_53 N005_53_M2_53_s 0.01
R_VDD_M2_53_b VDD VDD_M2_53_b 0.01
M2_53 N003_53_M2_53_d B_53_M2_53_g N005_53_M2_53_s VDD_M2_53_b pmos l=1u w=4u
R_VDD_M3_53_d VDD VDD_M3_53_d 0.01
R_A_53_M3_53_g A_53 A_53_M3_53_g 0.01
R_N001_53_M3_53_s N001_53 N001_53_M3_53_s 0.01
R_VDD_M3_53_b VDD VDD_M3_53_b 0.01
M3_53 VDD_M3_53_d A_53_M3_53_g N001_53_M3_53_s VDD_M3_53_b pmos l=1u w=4u
R_N001_53_M4_53_d N001_53 N001_53_M4_53_d 0.01
R_C_53_M4_53_g C_53 C_53_M4_53_g 0.01
R_N005_53_M4_53_s N005_53 N005_53_M4_53_s 0.01
R_VDD_M4_53_b VDD VDD_M4_53_b 0.01
M4_53 N001_53_M4_53_d C_53_M4_53_g N005_53_M4_53_s VDD_M4_53_b pmos l=1u w=4u
R_VDD_M5_53_d VDD VDD_M5_53_d 0.01
R_B_53_M5_53_g B_53 B_53_M5_53_g 0.01
R_N001_53_M5_53_s N001_53 N001_53_M5_53_s 0.01
R_VDD_M5_53_b VDD VDD_M5_53_b 0.01
M5_53 VDD_M5_53_d B_53_M5_53_g N001_53_M5_53_s VDD_M5_53_b pmos l=1u w=4u
R_VDD_M6_53_d VDD VDD_M6_53_d 0.01
R_N005_53_M6_53_g N005_53 N005_53_M6_53_g 0.01
R_C_54_M6_53_s C_54 C_54_M6_53_s 0.01
R_VDD_M6_53_b VDD VDD_M6_53_b 0.01
M6_53 VDD_M6_53_d N005_53_M6_53_g C_54_M6_53_s VDD_M6_53_b pmos l=1u w=2u
R_VDD_M7_53_d VDD VDD_M7_53_d 0.01
R_A_53_M7_53_g A_53 A_53_M7_53_g 0.01
R_N002_53_M7_53_s N002_53 N002_53_M7_53_s 0.01
R_VDD_M7_53_b VDD VDD_M7_53_b 0.01
M7_53 VDD_M7_53_d A_53_M7_53_g N002_53_M7_53_s VDD_M7_53_b pmos l=1u w=4u
R_VDD_M8_53_d VDD VDD_M8_53_d 0.01
R_B_53_M8_53_g B_53 B_53_M8_53_g 0.01
R_N002_53_M8_53_s N002_53 N002_53_M8_53_s 0.01
R_VDD_M8_53_b VDD VDD_M8_53_b 0.01
M8_53 VDD_M8_53_d B_53_M8_53_g N002_53_M8_53_s VDD_M8_53_b pmos l=1u w=4u
R_VDD_M9_53_d VDD VDD_M9_53_d 0.01
R_C_53_M9_53_g C_53 C_53_M9_53_g 0.01
R_N002_53_M9_53_s N002_53 N002_53_M9_53_s 0.01
R_VDD_M9_53_b VDD VDD_M9_53_b 0.01
M9_53 VDD_M9_53_d C_53_M9_53_g N002_53_M9_53_s VDD_M9_53_b pmos l=1u w=4u
R_VDD_M10_53_d VDD VDD_M10_53_d 0.01
R_A_53_M10_53_g A_53 A_53_M10_53_g 0.01
R_N004_53_M10_53_s N004_53 N004_53_M10_53_s 0.01
R_VDD_M10_53_b VDD VDD_M10_53_b 0.01
M10_53 VDD_M10_53_d A_53_M10_53_g N004_53_M10_53_s VDD_M10_53_b pmos l=1u w=8u
R_N004_53_M11_53_d N004_53 N004_53_M11_53_d 0.01
R_B_53_M11_53_g B_53 B_53_M11_53_g 0.01
R_N006_53_M11_53_s N006_53 N006_53_M11_53_s 0.01
R_VDD_M11_53_b VDD VDD_M11_53_b 0.01
M11_53 N004_53_M11_53_d B_53_M11_53_g N006_53_M11_53_s VDD_M11_53_b pmos l=1u w=8u
R_N006_53_M12_53_d N006_53 N006_53_M12_53_d 0.01
R_C_53_M12_53_g C_53 C_53_M12_53_g 0.01
R_N007_53_M12_53_s N007_53 N007_53_M12_53_s 0.01
R_VDD_M12_53_b VDD VDD_M12_53_b 0.01
M12_53 N006_53_M12_53_d C_53_M12_53_g N007_53_M12_53_s VDD_M12_53_b pmos l=1u w=8u
R_N007_53_M13_53_d N007_53 N007_53_M13_53_d 0.01
R_C_53_M13_53_g C_53 C_53_M13_53_g 0.01
R_N008_53_M13_53_s N008_53 N008_53_M13_53_s 0.01
M13_53 N007_53_M13_53_d C_53_M13_53_g N008_53_M13_53_s 0 nmos l=1u w=8u
R_N008_53_M14_53_d N008_53 N008_53_M14_53_d 0.01
R_B_53_M14_53_g B_53 B_53_M14_53_g 0.01
R_N012_53_M14_53_s N012_53 N012_53_M14_53_s 0.01
M14_53 N008_53_M14_53_d B_53_M14_53_g N012_53_M14_53_s 0 nmos l=1u w=8u
R_N012_53_M15_53_d N012_53 N012_53_M15_53_d 0.01
R_A_53_M15_53_g A_53 A_53_M15_53_g 0.01
M15_53 N012_53_M15_53_d A_53_M15_53_g 0 0 nmos l=1u w=8u
R_N010_53_M16_53_d N010_53 N010_53_M16_53_d 0.01
R_C_53_M16_53_g C_53 C_53_M16_53_g 0.01
M16_53 N010_53_M16_53_d C_53_M16_53_g 0 0 nmos l=1u w=2u
R_N010_53_M17_53_d N010_53 N010_53_M17_53_d 0.01
R_B_53_M17_53_g B_53 B_53_M17_53_g 0.01
M17_53 N010_53_M17_53_d B_53_M17_53_g 0 0 nmos l=1u w=2u
R_N010_53_M18_53_d N010_53 N010_53_M18_53_d 0.01
R_A_53_M18_53_g A_53 A_53_M18_53_g 0.01
M18_53 N010_53_M18_53_d A_53_M18_53_g 0 0 nmos l=1u w=2u
R_N007_53_M19_53_d N007_53 N007_53_M19_53_d 0.01
R_N005_53_M19_53_g N005_53 N005_53_M19_53_g 0.01
R_N010_53_M19_53_s N010_53 N010_53_M19_53_s 0.01
M19_53 N007_53_M19_53_d N005_53_M19_53_g N010_53_M19_53_s 0 nmos l=1u w=2u
R_N009_53_M20_53_d N009_53 N009_53_M20_53_d 0.01
R_B_53_M20_53_g B_53 B_53_M20_53_g 0.01
M20_53 N009_53_M20_53_d B_53_M20_53_g 0 0 nmos l=1u w=2u
R_N009_53_M21_53_d N009_53 N009_53_M21_53_d 0.01
R_A_53_M21_53_g A_53 A_53_M21_53_g 0.01
M21_53 N009_53_M21_53_d A_53_M21_53_g 0 0 nmos l=1u w=2u
R_N011_53_M22_53_d N011_53 N011_53_M22_53_d 0.01
R_A_53_M22_53_g A_53 A_53_M22_53_g 0.01
M22_53 N011_53_M22_53_d A_53_M22_53_g 0 0 nmos l=1u w=2u
R_N005_53_M23_53_d N005_53 N005_53_M23_53_d 0.01
R_B_53_M23_53_g B_53 B_53_M23_53_g 0.01
R_N011_53_M23_53_s N011_53 N011_53_M23_53_s 0.01
M23_53 N005_53_M23_53_d B_53_M23_53_g N011_53_M23_53_s 0 nmos l=1u w=2u
R_N005_53_M24_53_d N005_53 N005_53_M24_53_d 0.01
R_C_53_M24_53_g C_53 C_53_M24_53_g 0.01
R_N009_53_M24_53_s N009_53 N009_53_M24_53_s 0.01
M24_53 N005_53_M24_53_d C_53_M24_53_g N009_53_M24_53_s 0 nmos l=1u w=2u
R_C_54_M25_53_d C_54 C_54_M25_53_d 0.01
R_N005_53_M25_53_g N005_53 N005_53_M25_53_g 0.01
M25_53 C_54_M25_53_d N005_53_M25_53_g 0 0 nmos l=1u w=1u
R_N002_53_M26_53_d N002_53 N002_53_M26_53_d 0.01
R_N005_53_M26_53_g N005_53 N005_53_M26_53_g 0.01
R_N007_53_M26_53_s N007_53 N007_53_M26_53_s 0.01
R_VDD_M26_53_b VDD VDD_M26_53_b 0.01
M26_53 N002_53_M26_53_d N005_53_M26_53_g N007_53_M26_53_s VDD_M26_53_b pmos l=1u w=4u
R_VDD_M27_53_d VDD VDD_M27_53_d 0.01
R_N007_53_M27_53_g N007_53 N007_53_M27_53_g 0.01
R_S_53_M27_53_s S_53 S_53_M27_53_s 0.01
R_VDD_M27_53_b VDD VDD_M27_53_b 0.01
M27_53 VDD_M27_53_d N007_53_M27_53_g S_53_M27_53_s VDD_M27_53_b pmos l=1u w=2u
R_S_53_M28_53_d S_53 S_53_M28_53_d 0.01
R_N007_53_M28_53_g N007_53 N007_53_M28_53_g 0.01
M28_53 S_53_M28_53_d N007_53_M28_53_g 0 0 nmos l=1u w=1u
C_S_53 S_53 0 1f
* --- Bit 54 ---
R_VDD_M1_54_d VDD VDD_M1_54_d 0.01
R_A_54_M1_54_g A_54 A_54_M1_54_g 0.01
R_N003_54_M1_54_s N003_54 N003_54_M1_54_s 0.01
R_VDD_M1_54_b VDD VDD_M1_54_b 0.01
M1_54 VDD_M1_54_d A_54_M1_54_g N003_54_M1_54_s VDD_M1_54_b pmos l=1u w=4u
R_N003_54_M2_54_d N003_54 N003_54_M2_54_d 0.01
R_B_54_M2_54_g B_54 B_54_M2_54_g 0.01
R_N005_54_M2_54_s N005_54 N005_54_M2_54_s 0.01
R_VDD_M2_54_b VDD VDD_M2_54_b 0.01
M2_54 N003_54_M2_54_d B_54_M2_54_g N005_54_M2_54_s VDD_M2_54_b pmos l=1u w=4u
R_VDD_M3_54_d VDD VDD_M3_54_d 0.01
R_A_54_M3_54_g A_54 A_54_M3_54_g 0.01
R_N001_54_M3_54_s N001_54 N001_54_M3_54_s 0.01
R_VDD_M3_54_b VDD VDD_M3_54_b 0.01
M3_54 VDD_M3_54_d A_54_M3_54_g N001_54_M3_54_s VDD_M3_54_b pmos l=1u w=4u
R_N001_54_M4_54_d N001_54 N001_54_M4_54_d 0.01
R_C_54_M4_54_g C_54 C_54_M4_54_g 0.01
R_N005_54_M4_54_s N005_54 N005_54_M4_54_s 0.01
R_VDD_M4_54_b VDD VDD_M4_54_b 0.01
M4_54 N001_54_M4_54_d C_54_M4_54_g N005_54_M4_54_s VDD_M4_54_b pmos l=1u w=4u
R_VDD_M5_54_d VDD VDD_M5_54_d 0.01
R_B_54_M5_54_g B_54 B_54_M5_54_g 0.01
R_N001_54_M5_54_s N001_54 N001_54_M5_54_s 0.01
R_VDD_M5_54_b VDD VDD_M5_54_b 0.01
M5_54 VDD_M5_54_d B_54_M5_54_g N001_54_M5_54_s VDD_M5_54_b pmos l=1u w=4u
R_VDD_M6_54_d VDD VDD_M6_54_d 0.01
R_N005_54_M6_54_g N005_54 N005_54_M6_54_g 0.01
R_C_55_M6_54_s C_55 C_55_M6_54_s 0.01
R_VDD_M6_54_b VDD VDD_M6_54_b 0.01
M6_54 VDD_M6_54_d N005_54_M6_54_g C_55_M6_54_s VDD_M6_54_b pmos l=1u w=2u
R_VDD_M7_54_d VDD VDD_M7_54_d 0.01
R_A_54_M7_54_g A_54 A_54_M7_54_g 0.01
R_N002_54_M7_54_s N002_54 N002_54_M7_54_s 0.01
R_VDD_M7_54_b VDD VDD_M7_54_b 0.01
M7_54 VDD_M7_54_d A_54_M7_54_g N002_54_M7_54_s VDD_M7_54_b pmos l=1u w=4u
R_VDD_M8_54_d VDD VDD_M8_54_d 0.01
R_B_54_M8_54_g B_54 B_54_M8_54_g 0.01
R_N002_54_M8_54_s N002_54 N002_54_M8_54_s 0.01
R_VDD_M8_54_b VDD VDD_M8_54_b 0.01
M8_54 VDD_M8_54_d B_54_M8_54_g N002_54_M8_54_s VDD_M8_54_b pmos l=1u w=4u
R_VDD_M9_54_d VDD VDD_M9_54_d 0.01
R_C_54_M9_54_g C_54 C_54_M9_54_g 0.01
R_N002_54_M9_54_s N002_54 N002_54_M9_54_s 0.01
R_VDD_M9_54_b VDD VDD_M9_54_b 0.01
M9_54 VDD_M9_54_d C_54_M9_54_g N002_54_M9_54_s VDD_M9_54_b pmos l=1u w=4u
R_VDD_M10_54_d VDD VDD_M10_54_d 0.01
R_A_54_M10_54_g A_54 A_54_M10_54_g 0.01
R_N004_54_M10_54_s N004_54 N004_54_M10_54_s 0.01
R_VDD_M10_54_b VDD VDD_M10_54_b 0.01
M10_54 VDD_M10_54_d A_54_M10_54_g N004_54_M10_54_s VDD_M10_54_b pmos l=1u w=8u
R_N004_54_M11_54_d N004_54 N004_54_M11_54_d 0.01
R_B_54_M11_54_g B_54 B_54_M11_54_g 0.01
R_N006_54_M11_54_s N006_54 N006_54_M11_54_s 0.01
R_VDD_M11_54_b VDD VDD_M11_54_b 0.01
M11_54 N004_54_M11_54_d B_54_M11_54_g N006_54_M11_54_s VDD_M11_54_b pmos l=1u w=8u
R_N006_54_M12_54_d N006_54 N006_54_M12_54_d 0.01
R_C_54_M12_54_g C_54 C_54_M12_54_g 0.01
R_N007_54_M12_54_s N007_54 N007_54_M12_54_s 0.01
R_VDD_M12_54_b VDD VDD_M12_54_b 0.01
M12_54 N006_54_M12_54_d C_54_M12_54_g N007_54_M12_54_s VDD_M12_54_b pmos l=1u w=8u
R_N007_54_M13_54_d N007_54 N007_54_M13_54_d 0.01
R_C_54_M13_54_g C_54 C_54_M13_54_g 0.01
R_N008_54_M13_54_s N008_54 N008_54_M13_54_s 0.01
M13_54 N007_54_M13_54_d C_54_M13_54_g N008_54_M13_54_s 0 nmos l=1u w=8u
R_N008_54_M14_54_d N008_54 N008_54_M14_54_d 0.01
R_B_54_M14_54_g B_54 B_54_M14_54_g 0.01
R_N012_54_M14_54_s N012_54 N012_54_M14_54_s 0.01
M14_54 N008_54_M14_54_d B_54_M14_54_g N012_54_M14_54_s 0 nmos l=1u w=8u
R_N012_54_M15_54_d N012_54 N012_54_M15_54_d 0.01
R_A_54_M15_54_g A_54 A_54_M15_54_g 0.01
M15_54 N012_54_M15_54_d A_54_M15_54_g 0 0 nmos l=1u w=8u
R_N010_54_M16_54_d N010_54 N010_54_M16_54_d 0.01
R_C_54_M16_54_g C_54 C_54_M16_54_g 0.01
M16_54 N010_54_M16_54_d C_54_M16_54_g 0 0 nmos l=1u w=2u
R_N010_54_M17_54_d N010_54 N010_54_M17_54_d 0.01
R_B_54_M17_54_g B_54 B_54_M17_54_g 0.01
M17_54 N010_54_M17_54_d B_54_M17_54_g 0 0 nmos l=1u w=2u
R_N010_54_M18_54_d N010_54 N010_54_M18_54_d 0.01
R_A_54_M18_54_g A_54 A_54_M18_54_g 0.01
M18_54 N010_54_M18_54_d A_54_M18_54_g 0 0 nmos l=1u w=2u
R_N007_54_M19_54_d N007_54 N007_54_M19_54_d 0.01
R_N005_54_M19_54_g N005_54 N005_54_M19_54_g 0.01
R_N010_54_M19_54_s N010_54 N010_54_M19_54_s 0.01
M19_54 N007_54_M19_54_d N005_54_M19_54_g N010_54_M19_54_s 0 nmos l=1u w=2u
R_N009_54_M20_54_d N009_54 N009_54_M20_54_d 0.01
R_B_54_M20_54_g B_54 B_54_M20_54_g 0.01
M20_54 N009_54_M20_54_d B_54_M20_54_g 0 0 nmos l=1u w=2u
R_N009_54_M21_54_d N009_54 N009_54_M21_54_d 0.01
R_A_54_M21_54_g A_54 A_54_M21_54_g 0.01
M21_54 N009_54_M21_54_d A_54_M21_54_g 0 0 nmos l=1u w=2u
R_N011_54_M22_54_d N011_54 N011_54_M22_54_d 0.01
R_A_54_M22_54_g A_54 A_54_M22_54_g 0.01
M22_54 N011_54_M22_54_d A_54_M22_54_g 0 0 nmos l=1u w=2u
R_N005_54_M23_54_d N005_54 N005_54_M23_54_d 0.01
R_B_54_M23_54_g B_54 B_54_M23_54_g 0.01
R_N011_54_M23_54_s N011_54 N011_54_M23_54_s 0.01
M23_54 N005_54_M23_54_d B_54_M23_54_g N011_54_M23_54_s 0 nmos l=1u w=2u
R_N005_54_M24_54_d N005_54 N005_54_M24_54_d 0.01
R_C_54_M24_54_g C_54 C_54_M24_54_g 0.01
R_N009_54_M24_54_s N009_54 N009_54_M24_54_s 0.01
M24_54 N005_54_M24_54_d C_54_M24_54_g N009_54_M24_54_s 0 nmos l=1u w=2u
R_C_55_M25_54_d C_55 C_55_M25_54_d 0.01
R_N005_54_M25_54_g N005_54 N005_54_M25_54_g 0.01
M25_54 C_55_M25_54_d N005_54_M25_54_g 0 0 nmos l=1u w=1u
R_N002_54_M26_54_d N002_54 N002_54_M26_54_d 0.01
R_N005_54_M26_54_g N005_54 N005_54_M26_54_g 0.01
R_N007_54_M26_54_s N007_54 N007_54_M26_54_s 0.01
R_VDD_M26_54_b VDD VDD_M26_54_b 0.01
M26_54 N002_54_M26_54_d N005_54_M26_54_g N007_54_M26_54_s VDD_M26_54_b pmos l=1u w=4u
R_VDD_M27_54_d VDD VDD_M27_54_d 0.01
R_N007_54_M27_54_g N007_54 N007_54_M27_54_g 0.01
R_S_54_M27_54_s S_54 S_54_M27_54_s 0.01
R_VDD_M27_54_b VDD VDD_M27_54_b 0.01
M27_54 VDD_M27_54_d N007_54_M27_54_g S_54_M27_54_s VDD_M27_54_b pmos l=1u w=2u
R_S_54_M28_54_d S_54 S_54_M28_54_d 0.01
R_N007_54_M28_54_g N007_54 N007_54_M28_54_g 0.01
M28_54 S_54_M28_54_d N007_54_M28_54_g 0 0 nmos l=1u w=1u
C_S_54 S_54 0 1f
* --- Bit 55 ---
R_VDD_M1_55_d VDD VDD_M1_55_d 0.01
R_A_55_M1_55_g A_55 A_55_M1_55_g 0.01
R_N003_55_M1_55_s N003_55 N003_55_M1_55_s 0.01
R_VDD_M1_55_b VDD VDD_M1_55_b 0.01
M1_55 VDD_M1_55_d A_55_M1_55_g N003_55_M1_55_s VDD_M1_55_b pmos l=1u w=4u
R_N003_55_M2_55_d N003_55 N003_55_M2_55_d 0.01
R_B_55_M2_55_g B_55 B_55_M2_55_g 0.01
R_N005_55_M2_55_s N005_55 N005_55_M2_55_s 0.01
R_VDD_M2_55_b VDD VDD_M2_55_b 0.01
M2_55 N003_55_M2_55_d B_55_M2_55_g N005_55_M2_55_s VDD_M2_55_b pmos l=1u w=4u
R_VDD_M3_55_d VDD VDD_M3_55_d 0.01
R_A_55_M3_55_g A_55 A_55_M3_55_g 0.01
R_N001_55_M3_55_s N001_55 N001_55_M3_55_s 0.01
R_VDD_M3_55_b VDD VDD_M3_55_b 0.01
M3_55 VDD_M3_55_d A_55_M3_55_g N001_55_M3_55_s VDD_M3_55_b pmos l=1u w=4u
R_N001_55_M4_55_d N001_55 N001_55_M4_55_d 0.01
R_C_55_M4_55_g C_55 C_55_M4_55_g 0.01
R_N005_55_M4_55_s N005_55 N005_55_M4_55_s 0.01
R_VDD_M4_55_b VDD VDD_M4_55_b 0.01
M4_55 N001_55_M4_55_d C_55_M4_55_g N005_55_M4_55_s VDD_M4_55_b pmos l=1u w=4u
R_VDD_M5_55_d VDD VDD_M5_55_d 0.01
R_B_55_M5_55_g B_55 B_55_M5_55_g 0.01
R_N001_55_M5_55_s N001_55 N001_55_M5_55_s 0.01
R_VDD_M5_55_b VDD VDD_M5_55_b 0.01
M5_55 VDD_M5_55_d B_55_M5_55_g N001_55_M5_55_s VDD_M5_55_b pmos l=1u w=4u
R_VDD_M6_55_d VDD VDD_M6_55_d 0.01
R_N005_55_M6_55_g N005_55 N005_55_M6_55_g 0.01
R_C_56_M6_55_s C_56 C_56_M6_55_s 0.01
R_VDD_M6_55_b VDD VDD_M6_55_b 0.01
M6_55 VDD_M6_55_d N005_55_M6_55_g C_56_M6_55_s VDD_M6_55_b pmos l=1u w=2u
R_VDD_M7_55_d VDD VDD_M7_55_d 0.01
R_A_55_M7_55_g A_55 A_55_M7_55_g 0.01
R_N002_55_M7_55_s N002_55 N002_55_M7_55_s 0.01
R_VDD_M7_55_b VDD VDD_M7_55_b 0.01
M7_55 VDD_M7_55_d A_55_M7_55_g N002_55_M7_55_s VDD_M7_55_b pmos l=1u w=4u
R_VDD_M8_55_d VDD VDD_M8_55_d 0.01
R_B_55_M8_55_g B_55 B_55_M8_55_g 0.01
R_N002_55_M8_55_s N002_55 N002_55_M8_55_s 0.01
R_VDD_M8_55_b VDD VDD_M8_55_b 0.01
M8_55 VDD_M8_55_d B_55_M8_55_g N002_55_M8_55_s VDD_M8_55_b pmos l=1u w=4u
R_VDD_M9_55_d VDD VDD_M9_55_d 0.01
R_C_55_M9_55_g C_55 C_55_M9_55_g 0.01
R_N002_55_M9_55_s N002_55 N002_55_M9_55_s 0.01
R_VDD_M9_55_b VDD VDD_M9_55_b 0.01
M9_55 VDD_M9_55_d C_55_M9_55_g N002_55_M9_55_s VDD_M9_55_b pmos l=1u w=4u
R_VDD_M10_55_d VDD VDD_M10_55_d 0.01
R_A_55_M10_55_g A_55 A_55_M10_55_g 0.01
R_N004_55_M10_55_s N004_55 N004_55_M10_55_s 0.01
R_VDD_M10_55_b VDD VDD_M10_55_b 0.01
M10_55 VDD_M10_55_d A_55_M10_55_g N004_55_M10_55_s VDD_M10_55_b pmos l=1u w=8u
R_N004_55_M11_55_d N004_55 N004_55_M11_55_d 0.01
R_B_55_M11_55_g B_55 B_55_M11_55_g 0.01
R_N006_55_M11_55_s N006_55 N006_55_M11_55_s 0.01
R_VDD_M11_55_b VDD VDD_M11_55_b 0.01
M11_55 N004_55_M11_55_d B_55_M11_55_g N006_55_M11_55_s VDD_M11_55_b pmos l=1u w=8u
R_N006_55_M12_55_d N006_55 N006_55_M12_55_d 0.01
R_C_55_M12_55_g C_55 C_55_M12_55_g 0.01
R_N007_55_M12_55_s N007_55 N007_55_M12_55_s 0.01
R_VDD_M12_55_b VDD VDD_M12_55_b 0.01
M12_55 N006_55_M12_55_d C_55_M12_55_g N007_55_M12_55_s VDD_M12_55_b pmos l=1u w=8u
R_N007_55_M13_55_d N007_55 N007_55_M13_55_d 0.01
R_C_55_M13_55_g C_55 C_55_M13_55_g 0.01
R_N008_55_M13_55_s N008_55 N008_55_M13_55_s 0.01
M13_55 N007_55_M13_55_d C_55_M13_55_g N008_55_M13_55_s 0 nmos l=1u w=8u
R_N008_55_M14_55_d N008_55 N008_55_M14_55_d 0.01
R_B_55_M14_55_g B_55 B_55_M14_55_g 0.01
R_N012_55_M14_55_s N012_55 N012_55_M14_55_s 0.01
M14_55 N008_55_M14_55_d B_55_M14_55_g N012_55_M14_55_s 0 nmos l=1u w=8u
R_N012_55_M15_55_d N012_55 N012_55_M15_55_d 0.01
R_A_55_M15_55_g A_55 A_55_M15_55_g 0.01
M15_55 N012_55_M15_55_d A_55_M15_55_g 0 0 nmos l=1u w=8u
R_N010_55_M16_55_d N010_55 N010_55_M16_55_d 0.01
R_C_55_M16_55_g C_55 C_55_M16_55_g 0.01
M16_55 N010_55_M16_55_d C_55_M16_55_g 0 0 nmos l=1u w=2u
R_N010_55_M17_55_d N010_55 N010_55_M17_55_d 0.01
R_B_55_M17_55_g B_55 B_55_M17_55_g 0.01
M17_55 N010_55_M17_55_d B_55_M17_55_g 0 0 nmos l=1u w=2u
R_N010_55_M18_55_d N010_55 N010_55_M18_55_d 0.01
R_A_55_M18_55_g A_55 A_55_M18_55_g 0.01
M18_55 N010_55_M18_55_d A_55_M18_55_g 0 0 nmos l=1u w=2u
R_N007_55_M19_55_d N007_55 N007_55_M19_55_d 0.01
R_N005_55_M19_55_g N005_55 N005_55_M19_55_g 0.01
R_N010_55_M19_55_s N010_55 N010_55_M19_55_s 0.01
M19_55 N007_55_M19_55_d N005_55_M19_55_g N010_55_M19_55_s 0 nmos l=1u w=2u
R_N009_55_M20_55_d N009_55 N009_55_M20_55_d 0.01
R_B_55_M20_55_g B_55 B_55_M20_55_g 0.01
M20_55 N009_55_M20_55_d B_55_M20_55_g 0 0 nmos l=1u w=2u
R_N009_55_M21_55_d N009_55 N009_55_M21_55_d 0.01
R_A_55_M21_55_g A_55 A_55_M21_55_g 0.01
M21_55 N009_55_M21_55_d A_55_M21_55_g 0 0 nmos l=1u w=2u
R_N011_55_M22_55_d N011_55 N011_55_M22_55_d 0.01
R_A_55_M22_55_g A_55 A_55_M22_55_g 0.01
M22_55 N011_55_M22_55_d A_55_M22_55_g 0 0 nmos l=1u w=2u
R_N005_55_M23_55_d N005_55 N005_55_M23_55_d 0.01
R_B_55_M23_55_g B_55 B_55_M23_55_g 0.01
R_N011_55_M23_55_s N011_55 N011_55_M23_55_s 0.01
M23_55 N005_55_M23_55_d B_55_M23_55_g N011_55_M23_55_s 0 nmos l=1u w=2u
R_N005_55_M24_55_d N005_55 N005_55_M24_55_d 0.01
R_C_55_M24_55_g C_55 C_55_M24_55_g 0.01
R_N009_55_M24_55_s N009_55 N009_55_M24_55_s 0.01
M24_55 N005_55_M24_55_d C_55_M24_55_g N009_55_M24_55_s 0 nmos l=1u w=2u
R_C_56_M25_55_d C_56 C_56_M25_55_d 0.01
R_N005_55_M25_55_g N005_55 N005_55_M25_55_g 0.01
M25_55 C_56_M25_55_d N005_55_M25_55_g 0 0 nmos l=1u w=1u
R_N002_55_M26_55_d N002_55 N002_55_M26_55_d 0.01
R_N005_55_M26_55_g N005_55 N005_55_M26_55_g 0.01
R_N007_55_M26_55_s N007_55 N007_55_M26_55_s 0.01
R_VDD_M26_55_b VDD VDD_M26_55_b 0.01
M26_55 N002_55_M26_55_d N005_55_M26_55_g N007_55_M26_55_s VDD_M26_55_b pmos l=1u w=4u
R_VDD_M27_55_d VDD VDD_M27_55_d 0.01
R_N007_55_M27_55_g N007_55 N007_55_M27_55_g 0.01
R_S_55_M27_55_s S_55 S_55_M27_55_s 0.01
R_VDD_M27_55_b VDD VDD_M27_55_b 0.01
M27_55 VDD_M27_55_d N007_55_M27_55_g S_55_M27_55_s VDD_M27_55_b pmos l=1u w=2u
R_S_55_M28_55_d S_55 S_55_M28_55_d 0.01
R_N007_55_M28_55_g N007_55 N007_55_M28_55_g 0.01
M28_55 S_55_M28_55_d N007_55_M28_55_g 0 0 nmos l=1u w=1u
C_S_55 S_55 0 1f
* --- Bit 56 ---
R_VDD_M1_56_d VDD VDD_M1_56_d 0.01
R_A_56_M1_56_g A_56 A_56_M1_56_g 0.01
R_N003_56_M1_56_s N003_56 N003_56_M1_56_s 0.01
R_VDD_M1_56_b VDD VDD_M1_56_b 0.01
M1_56 VDD_M1_56_d A_56_M1_56_g N003_56_M1_56_s VDD_M1_56_b pmos l=1u w=4u
R_N003_56_M2_56_d N003_56 N003_56_M2_56_d 0.01
R_B_56_M2_56_g B_56 B_56_M2_56_g 0.01
R_N005_56_M2_56_s N005_56 N005_56_M2_56_s 0.01
R_VDD_M2_56_b VDD VDD_M2_56_b 0.01
M2_56 N003_56_M2_56_d B_56_M2_56_g N005_56_M2_56_s VDD_M2_56_b pmos l=1u w=4u
R_VDD_M3_56_d VDD VDD_M3_56_d 0.01
R_A_56_M3_56_g A_56 A_56_M3_56_g 0.01
R_N001_56_M3_56_s N001_56 N001_56_M3_56_s 0.01
R_VDD_M3_56_b VDD VDD_M3_56_b 0.01
M3_56 VDD_M3_56_d A_56_M3_56_g N001_56_M3_56_s VDD_M3_56_b pmos l=1u w=4u
R_N001_56_M4_56_d N001_56 N001_56_M4_56_d 0.01
R_C_56_M4_56_g C_56 C_56_M4_56_g 0.01
R_N005_56_M4_56_s N005_56 N005_56_M4_56_s 0.01
R_VDD_M4_56_b VDD VDD_M4_56_b 0.01
M4_56 N001_56_M4_56_d C_56_M4_56_g N005_56_M4_56_s VDD_M4_56_b pmos l=1u w=4u
R_VDD_M5_56_d VDD VDD_M5_56_d 0.01
R_B_56_M5_56_g B_56 B_56_M5_56_g 0.01
R_N001_56_M5_56_s N001_56 N001_56_M5_56_s 0.01
R_VDD_M5_56_b VDD VDD_M5_56_b 0.01
M5_56 VDD_M5_56_d B_56_M5_56_g N001_56_M5_56_s VDD_M5_56_b pmos l=1u w=4u
R_VDD_M6_56_d VDD VDD_M6_56_d 0.01
R_N005_56_M6_56_g N005_56 N005_56_M6_56_g 0.01
R_C_57_M6_56_s C_57 C_57_M6_56_s 0.01
R_VDD_M6_56_b VDD VDD_M6_56_b 0.01
M6_56 VDD_M6_56_d N005_56_M6_56_g C_57_M6_56_s VDD_M6_56_b pmos l=1u w=2u
R_VDD_M7_56_d VDD VDD_M7_56_d 0.01
R_A_56_M7_56_g A_56 A_56_M7_56_g 0.01
R_N002_56_M7_56_s N002_56 N002_56_M7_56_s 0.01
R_VDD_M7_56_b VDD VDD_M7_56_b 0.01
M7_56 VDD_M7_56_d A_56_M7_56_g N002_56_M7_56_s VDD_M7_56_b pmos l=1u w=4u
R_VDD_M8_56_d VDD VDD_M8_56_d 0.01
R_B_56_M8_56_g B_56 B_56_M8_56_g 0.01
R_N002_56_M8_56_s N002_56 N002_56_M8_56_s 0.01
R_VDD_M8_56_b VDD VDD_M8_56_b 0.01
M8_56 VDD_M8_56_d B_56_M8_56_g N002_56_M8_56_s VDD_M8_56_b pmos l=1u w=4u
R_VDD_M9_56_d VDD VDD_M9_56_d 0.01
R_C_56_M9_56_g C_56 C_56_M9_56_g 0.01
R_N002_56_M9_56_s N002_56 N002_56_M9_56_s 0.01
R_VDD_M9_56_b VDD VDD_M9_56_b 0.01
M9_56 VDD_M9_56_d C_56_M9_56_g N002_56_M9_56_s VDD_M9_56_b pmos l=1u w=4u
R_VDD_M10_56_d VDD VDD_M10_56_d 0.01
R_A_56_M10_56_g A_56 A_56_M10_56_g 0.01
R_N004_56_M10_56_s N004_56 N004_56_M10_56_s 0.01
R_VDD_M10_56_b VDD VDD_M10_56_b 0.01
M10_56 VDD_M10_56_d A_56_M10_56_g N004_56_M10_56_s VDD_M10_56_b pmos l=1u w=8u
R_N004_56_M11_56_d N004_56 N004_56_M11_56_d 0.01
R_B_56_M11_56_g B_56 B_56_M11_56_g 0.01
R_N006_56_M11_56_s N006_56 N006_56_M11_56_s 0.01
R_VDD_M11_56_b VDD VDD_M11_56_b 0.01
M11_56 N004_56_M11_56_d B_56_M11_56_g N006_56_M11_56_s VDD_M11_56_b pmos l=1u w=8u
R_N006_56_M12_56_d N006_56 N006_56_M12_56_d 0.01
R_C_56_M12_56_g C_56 C_56_M12_56_g 0.01
R_N007_56_M12_56_s N007_56 N007_56_M12_56_s 0.01
R_VDD_M12_56_b VDD VDD_M12_56_b 0.01
M12_56 N006_56_M12_56_d C_56_M12_56_g N007_56_M12_56_s VDD_M12_56_b pmos l=1u w=8u
R_N007_56_M13_56_d N007_56 N007_56_M13_56_d 0.01
R_C_56_M13_56_g C_56 C_56_M13_56_g 0.01
R_N008_56_M13_56_s N008_56 N008_56_M13_56_s 0.01
M13_56 N007_56_M13_56_d C_56_M13_56_g N008_56_M13_56_s 0 nmos l=1u w=8u
R_N008_56_M14_56_d N008_56 N008_56_M14_56_d 0.01
R_B_56_M14_56_g B_56 B_56_M14_56_g 0.01
R_N012_56_M14_56_s N012_56 N012_56_M14_56_s 0.01
M14_56 N008_56_M14_56_d B_56_M14_56_g N012_56_M14_56_s 0 nmos l=1u w=8u
R_N012_56_M15_56_d N012_56 N012_56_M15_56_d 0.01
R_A_56_M15_56_g A_56 A_56_M15_56_g 0.01
M15_56 N012_56_M15_56_d A_56_M15_56_g 0 0 nmos l=1u w=8u
R_N010_56_M16_56_d N010_56 N010_56_M16_56_d 0.01
R_C_56_M16_56_g C_56 C_56_M16_56_g 0.01
M16_56 N010_56_M16_56_d C_56_M16_56_g 0 0 nmos l=1u w=2u
R_N010_56_M17_56_d N010_56 N010_56_M17_56_d 0.01
R_B_56_M17_56_g B_56 B_56_M17_56_g 0.01
M17_56 N010_56_M17_56_d B_56_M17_56_g 0 0 nmos l=1u w=2u
R_N010_56_M18_56_d N010_56 N010_56_M18_56_d 0.01
R_A_56_M18_56_g A_56 A_56_M18_56_g 0.01
M18_56 N010_56_M18_56_d A_56_M18_56_g 0 0 nmos l=1u w=2u
R_N007_56_M19_56_d N007_56 N007_56_M19_56_d 0.01
R_N005_56_M19_56_g N005_56 N005_56_M19_56_g 0.01
R_N010_56_M19_56_s N010_56 N010_56_M19_56_s 0.01
M19_56 N007_56_M19_56_d N005_56_M19_56_g N010_56_M19_56_s 0 nmos l=1u w=2u
R_N009_56_M20_56_d N009_56 N009_56_M20_56_d 0.01
R_B_56_M20_56_g B_56 B_56_M20_56_g 0.01
M20_56 N009_56_M20_56_d B_56_M20_56_g 0 0 nmos l=1u w=2u
R_N009_56_M21_56_d N009_56 N009_56_M21_56_d 0.01
R_A_56_M21_56_g A_56 A_56_M21_56_g 0.01
M21_56 N009_56_M21_56_d A_56_M21_56_g 0 0 nmos l=1u w=2u
R_N011_56_M22_56_d N011_56 N011_56_M22_56_d 0.01
R_A_56_M22_56_g A_56 A_56_M22_56_g 0.01
M22_56 N011_56_M22_56_d A_56_M22_56_g 0 0 nmos l=1u w=2u
R_N005_56_M23_56_d N005_56 N005_56_M23_56_d 0.01
R_B_56_M23_56_g B_56 B_56_M23_56_g 0.01
R_N011_56_M23_56_s N011_56 N011_56_M23_56_s 0.01
M23_56 N005_56_M23_56_d B_56_M23_56_g N011_56_M23_56_s 0 nmos l=1u w=2u
R_N005_56_M24_56_d N005_56 N005_56_M24_56_d 0.01
R_C_56_M24_56_g C_56 C_56_M24_56_g 0.01
R_N009_56_M24_56_s N009_56 N009_56_M24_56_s 0.01
M24_56 N005_56_M24_56_d C_56_M24_56_g N009_56_M24_56_s 0 nmos l=1u w=2u
R_C_57_M25_56_d C_57 C_57_M25_56_d 0.01
R_N005_56_M25_56_g N005_56 N005_56_M25_56_g 0.01
M25_56 C_57_M25_56_d N005_56_M25_56_g 0 0 nmos l=1u w=1u
R_N002_56_M26_56_d N002_56 N002_56_M26_56_d 0.01
R_N005_56_M26_56_g N005_56 N005_56_M26_56_g 0.01
R_N007_56_M26_56_s N007_56 N007_56_M26_56_s 0.01
R_VDD_M26_56_b VDD VDD_M26_56_b 0.01
M26_56 N002_56_M26_56_d N005_56_M26_56_g N007_56_M26_56_s VDD_M26_56_b pmos l=1u w=4u
R_VDD_M27_56_d VDD VDD_M27_56_d 0.01
R_N007_56_M27_56_g N007_56 N007_56_M27_56_g 0.01
R_S_56_M27_56_s S_56 S_56_M27_56_s 0.01
R_VDD_M27_56_b VDD VDD_M27_56_b 0.01
M27_56 VDD_M27_56_d N007_56_M27_56_g S_56_M27_56_s VDD_M27_56_b pmos l=1u w=2u
R_S_56_M28_56_d S_56 S_56_M28_56_d 0.01
R_N007_56_M28_56_g N007_56 N007_56_M28_56_g 0.01
M28_56 S_56_M28_56_d N007_56_M28_56_g 0 0 nmos l=1u w=1u
C_S_56 S_56 0 1f
* --- Bit 57 ---
R_VDD_M1_57_d VDD VDD_M1_57_d 0.01
R_A_57_M1_57_g A_57 A_57_M1_57_g 0.01
R_N003_57_M1_57_s N003_57 N003_57_M1_57_s 0.01
R_VDD_M1_57_b VDD VDD_M1_57_b 0.01
M1_57 VDD_M1_57_d A_57_M1_57_g N003_57_M1_57_s VDD_M1_57_b pmos l=1u w=4u
R_N003_57_M2_57_d N003_57 N003_57_M2_57_d 0.01
R_B_57_M2_57_g B_57 B_57_M2_57_g 0.01
R_N005_57_M2_57_s N005_57 N005_57_M2_57_s 0.01
R_VDD_M2_57_b VDD VDD_M2_57_b 0.01
M2_57 N003_57_M2_57_d B_57_M2_57_g N005_57_M2_57_s VDD_M2_57_b pmos l=1u w=4u
R_VDD_M3_57_d VDD VDD_M3_57_d 0.01
R_A_57_M3_57_g A_57 A_57_M3_57_g 0.01
R_N001_57_M3_57_s N001_57 N001_57_M3_57_s 0.01
R_VDD_M3_57_b VDD VDD_M3_57_b 0.01
M3_57 VDD_M3_57_d A_57_M3_57_g N001_57_M3_57_s VDD_M3_57_b pmos l=1u w=4u
R_N001_57_M4_57_d N001_57 N001_57_M4_57_d 0.01
R_C_57_M4_57_g C_57 C_57_M4_57_g 0.01
R_N005_57_M4_57_s N005_57 N005_57_M4_57_s 0.01
R_VDD_M4_57_b VDD VDD_M4_57_b 0.01
M4_57 N001_57_M4_57_d C_57_M4_57_g N005_57_M4_57_s VDD_M4_57_b pmos l=1u w=4u
R_VDD_M5_57_d VDD VDD_M5_57_d 0.01
R_B_57_M5_57_g B_57 B_57_M5_57_g 0.01
R_N001_57_M5_57_s N001_57 N001_57_M5_57_s 0.01
R_VDD_M5_57_b VDD VDD_M5_57_b 0.01
M5_57 VDD_M5_57_d B_57_M5_57_g N001_57_M5_57_s VDD_M5_57_b pmos l=1u w=4u
R_VDD_M6_57_d VDD VDD_M6_57_d 0.01
R_N005_57_M6_57_g N005_57 N005_57_M6_57_g 0.01
R_C_58_M6_57_s C_58 C_58_M6_57_s 0.01
R_VDD_M6_57_b VDD VDD_M6_57_b 0.01
M6_57 VDD_M6_57_d N005_57_M6_57_g C_58_M6_57_s VDD_M6_57_b pmos l=1u w=2u
R_VDD_M7_57_d VDD VDD_M7_57_d 0.01
R_A_57_M7_57_g A_57 A_57_M7_57_g 0.01
R_N002_57_M7_57_s N002_57 N002_57_M7_57_s 0.01
R_VDD_M7_57_b VDD VDD_M7_57_b 0.01
M7_57 VDD_M7_57_d A_57_M7_57_g N002_57_M7_57_s VDD_M7_57_b pmos l=1u w=4u
R_VDD_M8_57_d VDD VDD_M8_57_d 0.01
R_B_57_M8_57_g B_57 B_57_M8_57_g 0.01
R_N002_57_M8_57_s N002_57 N002_57_M8_57_s 0.01
R_VDD_M8_57_b VDD VDD_M8_57_b 0.01
M8_57 VDD_M8_57_d B_57_M8_57_g N002_57_M8_57_s VDD_M8_57_b pmos l=1u w=4u
R_VDD_M9_57_d VDD VDD_M9_57_d 0.01
R_C_57_M9_57_g C_57 C_57_M9_57_g 0.01
R_N002_57_M9_57_s N002_57 N002_57_M9_57_s 0.01
R_VDD_M9_57_b VDD VDD_M9_57_b 0.01
M9_57 VDD_M9_57_d C_57_M9_57_g N002_57_M9_57_s VDD_M9_57_b pmos l=1u w=4u
R_VDD_M10_57_d VDD VDD_M10_57_d 0.01
R_A_57_M10_57_g A_57 A_57_M10_57_g 0.01
R_N004_57_M10_57_s N004_57 N004_57_M10_57_s 0.01
R_VDD_M10_57_b VDD VDD_M10_57_b 0.01
M10_57 VDD_M10_57_d A_57_M10_57_g N004_57_M10_57_s VDD_M10_57_b pmos l=1u w=8u
R_N004_57_M11_57_d N004_57 N004_57_M11_57_d 0.01
R_B_57_M11_57_g B_57 B_57_M11_57_g 0.01
R_N006_57_M11_57_s N006_57 N006_57_M11_57_s 0.01
R_VDD_M11_57_b VDD VDD_M11_57_b 0.01
M11_57 N004_57_M11_57_d B_57_M11_57_g N006_57_M11_57_s VDD_M11_57_b pmos l=1u w=8u
R_N006_57_M12_57_d N006_57 N006_57_M12_57_d 0.01
R_C_57_M12_57_g C_57 C_57_M12_57_g 0.01
R_N007_57_M12_57_s N007_57 N007_57_M12_57_s 0.01
R_VDD_M12_57_b VDD VDD_M12_57_b 0.01
M12_57 N006_57_M12_57_d C_57_M12_57_g N007_57_M12_57_s VDD_M12_57_b pmos l=1u w=8u
R_N007_57_M13_57_d N007_57 N007_57_M13_57_d 0.01
R_C_57_M13_57_g C_57 C_57_M13_57_g 0.01
R_N008_57_M13_57_s N008_57 N008_57_M13_57_s 0.01
M13_57 N007_57_M13_57_d C_57_M13_57_g N008_57_M13_57_s 0 nmos l=1u w=8u
R_N008_57_M14_57_d N008_57 N008_57_M14_57_d 0.01
R_B_57_M14_57_g B_57 B_57_M14_57_g 0.01
R_N012_57_M14_57_s N012_57 N012_57_M14_57_s 0.01
M14_57 N008_57_M14_57_d B_57_M14_57_g N012_57_M14_57_s 0 nmos l=1u w=8u
R_N012_57_M15_57_d N012_57 N012_57_M15_57_d 0.01
R_A_57_M15_57_g A_57 A_57_M15_57_g 0.01
M15_57 N012_57_M15_57_d A_57_M15_57_g 0 0 nmos l=1u w=8u
R_N010_57_M16_57_d N010_57 N010_57_M16_57_d 0.01
R_C_57_M16_57_g C_57 C_57_M16_57_g 0.01
M16_57 N010_57_M16_57_d C_57_M16_57_g 0 0 nmos l=1u w=2u
R_N010_57_M17_57_d N010_57 N010_57_M17_57_d 0.01
R_B_57_M17_57_g B_57 B_57_M17_57_g 0.01
M17_57 N010_57_M17_57_d B_57_M17_57_g 0 0 nmos l=1u w=2u
R_N010_57_M18_57_d N010_57 N010_57_M18_57_d 0.01
R_A_57_M18_57_g A_57 A_57_M18_57_g 0.01
M18_57 N010_57_M18_57_d A_57_M18_57_g 0 0 nmos l=1u w=2u
R_N007_57_M19_57_d N007_57 N007_57_M19_57_d 0.01
R_N005_57_M19_57_g N005_57 N005_57_M19_57_g 0.01
R_N010_57_M19_57_s N010_57 N010_57_M19_57_s 0.01
M19_57 N007_57_M19_57_d N005_57_M19_57_g N010_57_M19_57_s 0 nmos l=1u w=2u
R_N009_57_M20_57_d N009_57 N009_57_M20_57_d 0.01
R_B_57_M20_57_g B_57 B_57_M20_57_g 0.01
M20_57 N009_57_M20_57_d B_57_M20_57_g 0 0 nmos l=1u w=2u
R_N009_57_M21_57_d N009_57 N009_57_M21_57_d 0.01
R_A_57_M21_57_g A_57 A_57_M21_57_g 0.01
M21_57 N009_57_M21_57_d A_57_M21_57_g 0 0 nmos l=1u w=2u
R_N011_57_M22_57_d N011_57 N011_57_M22_57_d 0.01
R_A_57_M22_57_g A_57 A_57_M22_57_g 0.01
M22_57 N011_57_M22_57_d A_57_M22_57_g 0 0 nmos l=1u w=2u
R_N005_57_M23_57_d N005_57 N005_57_M23_57_d 0.01
R_B_57_M23_57_g B_57 B_57_M23_57_g 0.01
R_N011_57_M23_57_s N011_57 N011_57_M23_57_s 0.01
M23_57 N005_57_M23_57_d B_57_M23_57_g N011_57_M23_57_s 0 nmos l=1u w=2u
R_N005_57_M24_57_d N005_57 N005_57_M24_57_d 0.01
R_C_57_M24_57_g C_57 C_57_M24_57_g 0.01
R_N009_57_M24_57_s N009_57 N009_57_M24_57_s 0.01
M24_57 N005_57_M24_57_d C_57_M24_57_g N009_57_M24_57_s 0 nmos l=1u w=2u
R_C_58_M25_57_d C_58 C_58_M25_57_d 0.01
R_N005_57_M25_57_g N005_57 N005_57_M25_57_g 0.01
M25_57 C_58_M25_57_d N005_57_M25_57_g 0 0 nmos l=1u w=1u
R_N002_57_M26_57_d N002_57 N002_57_M26_57_d 0.01
R_N005_57_M26_57_g N005_57 N005_57_M26_57_g 0.01
R_N007_57_M26_57_s N007_57 N007_57_M26_57_s 0.01
R_VDD_M26_57_b VDD VDD_M26_57_b 0.01
M26_57 N002_57_M26_57_d N005_57_M26_57_g N007_57_M26_57_s VDD_M26_57_b pmos l=1u w=4u
R_VDD_M27_57_d VDD VDD_M27_57_d 0.01
R_N007_57_M27_57_g N007_57 N007_57_M27_57_g 0.01
R_S_57_M27_57_s S_57 S_57_M27_57_s 0.01
R_VDD_M27_57_b VDD VDD_M27_57_b 0.01
M27_57 VDD_M27_57_d N007_57_M27_57_g S_57_M27_57_s VDD_M27_57_b pmos l=1u w=2u
R_S_57_M28_57_d S_57 S_57_M28_57_d 0.01
R_N007_57_M28_57_g N007_57 N007_57_M28_57_g 0.01
M28_57 S_57_M28_57_d N007_57_M28_57_g 0 0 nmos l=1u w=1u
C_S_57 S_57 0 1f
* --- Bit 58 ---
R_VDD_M1_58_d VDD VDD_M1_58_d 0.01
R_A_58_M1_58_g A_58 A_58_M1_58_g 0.01
R_N003_58_M1_58_s N003_58 N003_58_M1_58_s 0.01
R_VDD_M1_58_b VDD VDD_M1_58_b 0.01
M1_58 VDD_M1_58_d A_58_M1_58_g N003_58_M1_58_s VDD_M1_58_b pmos l=1u w=4u
R_N003_58_M2_58_d N003_58 N003_58_M2_58_d 0.01
R_B_58_M2_58_g B_58 B_58_M2_58_g 0.01
R_N005_58_M2_58_s N005_58 N005_58_M2_58_s 0.01
R_VDD_M2_58_b VDD VDD_M2_58_b 0.01
M2_58 N003_58_M2_58_d B_58_M2_58_g N005_58_M2_58_s VDD_M2_58_b pmos l=1u w=4u
R_VDD_M3_58_d VDD VDD_M3_58_d 0.01
R_A_58_M3_58_g A_58 A_58_M3_58_g 0.01
R_N001_58_M3_58_s N001_58 N001_58_M3_58_s 0.01
R_VDD_M3_58_b VDD VDD_M3_58_b 0.01
M3_58 VDD_M3_58_d A_58_M3_58_g N001_58_M3_58_s VDD_M3_58_b pmos l=1u w=4u
R_N001_58_M4_58_d N001_58 N001_58_M4_58_d 0.01
R_C_58_M4_58_g C_58 C_58_M4_58_g 0.01
R_N005_58_M4_58_s N005_58 N005_58_M4_58_s 0.01
R_VDD_M4_58_b VDD VDD_M4_58_b 0.01
M4_58 N001_58_M4_58_d C_58_M4_58_g N005_58_M4_58_s VDD_M4_58_b pmos l=1u w=4u
R_VDD_M5_58_d VDD VDD_M5_58_d 0.01
R_B_58_M5_58_g B_58 B_58_M5_58_g 0.01
R_N001_58_M5_58_s N001_58 N001_58_M5_58_s 0.01
R_VDD_M5_58_b VDD VDD_M5_58_b 0.01
M5_58 VDD_M5_58_d B_58_M5_58_g N001_58_M5_58_s VDD_M5_58_b pmos l=1u w=4u
R_VDD_M6_58_d VDD VDD_M6_58_d 0.01
R_N005_58_M6_58_g N005_58 N005_58_M6_58_g 0.01
R_C_59_M6_58_s C_59 C_59_M6_58_s 0.01
R_VDD_M6_58_b VDD VDD_M6_58_b 0.01
M6_58 VDD_M6_58_d N005_58_M6_58_g C_59_M6_58_s VDD_M6_58_b pmos l=1u w=2u
R_VDD_M7_58_d VDD VDD_M7_58_d 0.01
R_A_58_M7_58_g A_58 A_58_M7_58_g 0.01
R_N002_58_M7_58_s N002_58 N002_58_M7_58_s 0.01
R_VDD_M7_58_b VDD VDD_M7_58_b 0.01
M7_58 VDD_M7_58_d A_58_M7_58_g N002_58_M7_58_s VDD_M7_58_b pmos l=1u w=4u
R_VDD_M8_58_d VDD VDD_M8_58_d 0.01
R_B_58_M8_58_g B_58 B_58_M8_58_g 0.01
R_N002_58_M8_58_s N002_58 N002_58_M8_58_s 0.01
R_VDD_M8_58_b VDD VDD_M8_58_b 0.01
M8_58 VDD_M8_58_d B_58_M8_58_g N002_58_M8_58_s VDD_M8_58_b pmos l=1u w=4u
R_VDD_M9_58_d VDD VDD_M9_58_d 0.01
R_C_58_M9_58_g C_58 C_58_M9_58_g 0.01
R_N002_58_M9_58_s N002_58 N002_58_M9_58_s 0.01
R_VDD_M9_58_b VDD VDD_M9_58_b 0.01
M9_58 VDD_M9_58_d C_58_M9_58_g N002_58_M9_58_s VDD_M9_58_b pmos l=1u w=4u
R_VDD_M10_58_d VDD VDD_M10_58_d 0.01
R_A_58_M10_58_g A_58 A_58_M10_58_g 0.01
R_N004_58_M10_58_s N004_58 N004_58_M10_58_s 0.01
R_VDD_M10_58_b VDD VDD_M10_58_b 0.01
M10_58 VDD_M10_58_d A_58_M10_58_g N004_58_M10_58_s VDD_M10_58_b pmos l=1u w=8u
R_N004_58_M11_58_d N004_58 N004_58_M11_58_d 0.01
R_B_58_M11_58_g B_58 B_58_M11_58_g 0.01
R_N006_58_M11_58_s N006_58 N006_58_M11_58_s 0.01
R_VDD_M11_58_b VDD VDD_M11_58_b 0.01
M11_58 N004_58_M11_58_d B_58_M11_58_g N006_58_M11_58_s VDD_M11_58_b pmos l=1u w=8u
R_N006_58_M12_58_d N006_58 N006_58_M12_58_d 0.01
R_C_58_M12_58_g C_58 C_58_M12_58_g 0.01
R_N007_58_M12_58_s N007_58 N007_58_M12_58_s 0.01
R_VDD_M12_58_b VDD VDD_M12_58_b 0.01
M12_58 N006_58_M12_58_d C_58_M12_58_g N007_58_M12_58_s VDD_M12_58_b pmos l=1u w=8u
R_N007_58_M13_58_d N007_58 N007_58_M13_58_d 0.01
R_C_58_M13_58_g C_58 C_58_M13_58_g 0.01
R_N008_58_M13_58_s N008_58 N008_58_M13_58_s 0.01
M13_58 N007_58_M13_58_d C_58_M13_58_g N008_58_M13_58_s 0 nmos l=1u w=8u
R_N008_58_M14_58_d N008_58 N008_58_M14_58_d 0.01
R_B_58_M14_58_g B_58 B_58_M14_58_g 0.01
R_N012_58_M14_58_s N012_58 N012_58_M14_58_s 0.01
M14_58 N008_58_M14_58_d B_58_M14_58_g N012_58_M14_58_s 0 nmos l=1u w=8u
R_N012_58_M15_58_d N012_58 N012_58_M15_58_d 0.01
R_A_58_M15_58_g A_58 A_58_M15_58_g 0.01
M15_58 N012_58_M15_58_d A_58_M15_58_g 0 0 nmos l=1u w=8u
R_N010_58_M16_58_d N010_58 N010_58_M16_58_d 0.01
R_C_58_M16_58_g C_58 C_58_M16_58_g 0.01
M16_58 N010_58_M16_58_d C_58_M16_58_g 0 0 nmos l=1u w=2u
R_N010_58_M17_58_d N010_58 N010_58_M17_58_d 0.01
R_B_58_M17_58_g B_58 B_58_M17_58_g 0.01
M17_58 N010_58_M17_58_d B_58_M17_58_g 0 0 nmos l=1u w=2u
R_N010_58_M18_58_d N010_58 N010_58_M18_58_d 0.01
R_A_58_M18_58_g A_58 A_58_M18_58_g 0.01
M18_58 N010_58_M18_58_d A_58_M18_58_g 0 0 nmos l=1u w=2u
R_N007_58_M19_58_d N007_58 N007_58_M19_58_d 0.01
R_N005_58_M19_58_g N005_58 N005_58_M19_58_g 0.01
R_N010_58_M19_58_s N010_58 N010_58_M19_58_s 0.01
M19_58 N007_58_M19_58_d N005_58_M19_58_g N010_58_M19_58_s 0 nmos l=1u w=2u
R_N009_58_M20_58_d N009_58 N009_58_M20_58_d 0.01
R_B_58_M20_58_g B_58 B_58_M20_58_g 0.01
M20_58 N009_58_M20_58_d B_58_M20_58_g 0 0 nmos l=1u w=2u
R_N009_58_M21_58_d N009_58 N009_58_M21_58_d 0.01
R_A_58_M21_58_g A_58 A_58_M21_58_g 0.01
M21_58 N009_58_M21_58_d A_58_M21_58_g 0 0 nmos l=1u w=2u
R_N011_58_M22_58_d N011_58 N011_58_M22_58_d 0.01
R_A_58_M22_58_g A_58 A_58_M22_58_g 0.01
M22_58 N011_58_M22_58_d A_58_M22_58_g 0 0 nmos l=1u w=2u
R_N005_58_M23_58_d N005_58 N005_58_M23_58_d 0.01
R_B_58_M23_58_g B_58 B_58_M23_58_g 0.01
R_N011_58_M23_58_s N011_58 N011_58_M23_58_s 0.01
M23_58 N005_58_M23_58_d B_58_M23_58_g N011_58_M23_58_s 0 nmos l=1u w=2u
R_N005_58_M24_58_d N005_58 N005_58_M24_58_d 0.01
R_C_58_M24_58_g C_58 C_58_M24_58_g 0.01
R_N009_58_M24_58_s N009_58 N009_58_M24_58_s 0.01
M24_58 N005_58_M24_58_d C_58_M24_58_g N009_58_M24_58_s 0 nmos l=1u w=2u
R_C_59_M25_58_d C_59 C_59_M25_58_d 0.01
R_N005_58_M25_58_g N005_58 N005_58_M25_58_g 0.01
M25_58 C_59_M25_58_d N005_58_M25_58_g 0 0 nmos l=1u w=1u
R_N002_58_M26_58_d N002_58 N002_58_M26_58_d 0.01
R_N005_58_M26_58_g N005_58 N005_58_M26_58_g 0.01
R_N007_58_M26_58_s N007_58 N007_58_M26_58_s 0.01
R_VDD_M26_58_b VDD VDD_M26_58_b 0.01
M26_58 N002_58_M26_58_d N005_58_M26_58_g N007_58_M26_58_s VDD_M26_58_b pmos l=1u w=4u
R_VDD_M27_58_d VDD VDD_M27_58_d 0.01
R_N007_58_M27_58_g N007_58 N007_58_M27_58_g 0.01
R_S_58_M27_58_s S_58 S_58_M27_58_s 0.01
R_VDD_M27_58_b VDD VDD_M27_58_b 0.01
M27_58 VDD_M27_58_d N007_58_M27_58_g S_58_M27_58_s VDD_M27_58_b pmos l=1u w=2u
R_S_58_M28_58_d S_58 S_58_M28_58_d 0.01
R_N007_58_M28_58_g N007_58 N007_58_M28_58_g 0.01
M28_58 S_58_M28_58_d N007_58_M28_58_g 0 0 nmos l=1u w=1u
C_S_58 S_58 0 1f
* --- Bit 59 ---
R_VDD_M1_59_d VDD VDD_M1_59_d 0.01
R_A_59_M1_59_g A_59 A_59_M1_59_g 0.01
R_N003_59_M1_59_s N003_59 N003_59_M1_59_s 0.01
R_VDD_M1_59_b VDD VDD_M1_59_b 0.01
M1_59 VDD_M1_59_d A_59_M1_59_g N003_59_M1_59_s VDD_M1_59_b pmos l=1u w=4u
R_N003_59_M2_59_d N003_59 N003_59_M2_59_d 0.01
R_B_59_M2_59_g B_59 B_59_M2_59_g 0.01
R_N005_59_M2_59_s N005_59 N005_59_M2_59_s 0.01
R_VDD_M2_59_b VDD VDD_M2_59_b 0.01
M2_59 N003_59_M2_59_d B_59_M2_59_g N005_59_M2_59_s VDD_M2_59_b pmos l=1u w=4u
R_VDD_M3_59_d VDD VDD_M3_59_d 0.01
R_A_59_M3_59_g A_59 A_59_M3_59_g 0.01
R_N001_59_M3_59_s N001_59 N001_59_M3_59_s 0.01
R_VDD_M3_59_b VDD VDD_M3_59_b 0.01
M3_59 VDD_M3_59_d A_59_M3_59_g N001_59_M3_59_s VDD_M3_59_b pmos l=1u w=4u
R_N001_59_M4_59_d N001_59 N001_59_M4_59_d 0.01
R_C_59_M4_59_g C_59 C_59_M4_59_g 0.01
R_N005_59_M4_59_s N005_59 N005_59_M4_59_s 0.01
R_VDD_M4_59_b VDD VDD_M4_59_b 0.01
M4_59 N001_59_M4_59_d C_59_M4_59_g N005_59_M4_59_s VDD_M4_59_b pmos l=1u w=4u
R_VDD_M5_59_d VDD VDD_M5_59_d 0.01
R_B_59_M5_59_g B_59 B_59_M5_59_g 0.01
R_N001_59_M5_59_s N001_59 N001_59_M5_59_s 0.01
R_VDD_M5_59_b VDD VDD_M5_59_b 0.01
M5_59 VDD_M5_59_d B_59_M5_59_g N001_59_M5_59_s VDD_M5_59_b pmos l=1u w=4u
R_VDD_M6_59_d VDD VDD_M6_59_d 0.01
R_N005_59_M6_59_g N005_59 N005_59_M6_59_g 0.01
R_C_60_M6_59_s C_60 C_60_M6_59_s 0.01
R_VDD_M6_59_b VDD VDD_M6_59_b 0.01
M6_59 VDD_M6_59_d N005_59_M6_59_g C_60_M6_59_s VDD_M6_59_b pmos l=1u w=2u
R_VDD_M7_59_d VDD VDD_M7_59_d 0.01
R_A_59_M7_59_g A_59 A_59_M7_59_g 0.01
R_N002_59_M7_59_s N002_59 N002_59_M7_59_s 0.01
R_VDD_M7_59_b VDD VDD_M7_59_b 0.01
M7_59 VDD_M7_59_d A_59_M7_59_g N002_59_M7_59_s VDD_M7_59_b pmos l=1u w=4u
R_VDD_M8_59_d VDD VDD_M8_59_d 0.01
R_B_59_M8_59_g B_59 B_59_M8_59_g 0.01
R_N002_59_M8_59_s N002_59 N002_59_M8_59_s 0.01
R_VDD_M8_59_b VDD VDD_M8_59_b 0.01
M8_59 VDD_M8_59_d B_59_M8_59_g N002_59_M8_59_s VDD_M8_59_b pmos l=1u w=4u
R_VDD_M9_59_d VDD VDD_M9_59_d 0.01
R_C_59_M9_59_g C_59 C_59_M9_59_g 0.01
R_N002_59_M9_59_s N002_59 N002_59_M9_59_s 0.01
R_VDD_M9_59_b VDD VDD_M9_59_b 0.01
M9_59 VDD_M9_59_d C_59_M9_59_g N002_59_M9_59_s VDD_M9_59_b pmos l=1u w=4u
R_VDD_M10_59_d VDD VDD_M10_59_d 0.01
R_A_59_M10_59_g A_59 A_59_M10_59_g 0.01
R_N004_59_M10_59_s N004_59 N004_59_M10_59_s 0.01
R_VDD_M10_59_b VDD VDD_M10_59_b 0.01
M10_59 VDD_M10_59_d A_59_M10_59_g N004_59_M10_59_s VDD_M10_59_b pmos l=1u w=8u
R_N004_59_M11_59_d N004_59 N004_59_M11_59_d 0.01
R_B_59_M11_59_g B_59 B_59_M11_59_g 0.01
R_N006_59_M11_59_s N006_59 N006_59_M11_59_s 0.01
R_VDD_M11_59_b VDD VDD_M11_59_b 0.01
M11_59 N004_59_M11_59_d B_59_M11_59_g N006_59_M11_59_s VDD_M11_59_b pmos l=1u w=8u
R_N006_59_M12_59_d N006_59 N006_59_M12_59_d 0.01
R_C_59_M12_59_g C_59 C_59_M12_59_g 0.01
R_N007_59_M12_59_s N007_59 N007_59_M12_59_s 0.01
R_VDD_M12_59_b VDD VDD_M12_59_b 0.01
M12_59 N006_59_M12_59_d C_59_M12_59_g N007_59_M12_59_s VDD_M12_59_b pmos l=1u w=8u
R_N007_59_M13_59_d N007_59 N007_59_M13_59_d 0.01
R_C_59_M13_59_g C_59 C_59_M13_59_g 0.01
R_N008_59_M13_59_s N008_59 N008_59_M13_59_s 0.01
M13_59 N007_59_M13_59_d C_59_M13_59_g N008_59_M13_59_s 0 nmos l=1u w=8u
R_N008_59_M14_59_d N008_59 N008_59_M14_59_d 0.01
R_B_59_M14_59_g B_59 B_59_M14_59_g 0.01
R_N012_59_M14_59_s N012_59 N012_59_M14_59_s 0.01
M14_59 N008_59_M14_59_d B_59_M14_59_g N012_59_M14_59_s 0 nmos l=1u w=8u
R_N012_59_M15_59_d N012_59 N012_59_M15_59_d 0.01
R_A_59_M15_59_g A_59 A_59_M15_59_g 0.01
M15_59 N012_59_M15_59_d A_59_M15_59_g 0 0 nmos l=1u w=8u
R_N010_59_M16_59_d N010_59 N010_59_M16_59_d 0.01
R_C_59_M16_59_g C_59 C_59_M16_59_g 0.01
M16_59 N010_59_M16_59_d C_59_M16_59_g 0 0 nmos l=1u w=2u
R_N010_59_M17_59_d N010_59 N010_59_M17_59_d 0.01
R_B_59_M17_59_g B_59 B_59_M17_59_g 0.01
M17_59 N010_59_M17_59_d B_59_M17_59_g 0 0 nmos l=1u w=2u
R_N010_59_M18_59_d N010_59 N010_59_M18_59_d 0.01
R_A_59_M18_59_g A_59 A_59_M18_59_g 0.01
M18_59 N010_59_M18_59_d A_59_M18_59_g 0 0 nmos l=1u w=2u
R_N007_59_M19_59_d N007_59 N007_59_M19_59_d 0.01
R_N005_59_M19_59_g N005_59 N005_59_M19_59_g 0.01
R_N010_59_M19_59_s N010_59 N010_59_M19_59_s 0.01
M19_59 N007_59_M19_59_d N005_59_M19_59_g N010_59_M19_59_s 0 nmos l=1u w=2u
R_N009_59_M20_59_d N009_59 N009_59_M20_59_d 0.01
R_B_59_M20_59_g B_59 B_59_M20_59_g 0.01
M20_59 N009_59_M20_59_d B_59_M20_59_g 0 0 nmos l=1u w=2u
R_N009_59_M21_59_d N009_59 N009_59_M21_59_d 0.01
R_A_59_M21_59_g A_59 A_59_M21_59_g 0.01
M21_59 N009_59_M21_59_d A_59_M21_59_g 0 0 nmos l=1u w=2u
R_N011_59_M22_59_d N011_59 N011_59_M22_59_d 0.01
R_A_59_M22_59_g A_59 A_59_M22_59_g 0.01
M22_59 N011_59_M22_59_d A_59_M22_59_g 0 0 nmos l=1u w=2u
R_N005_59_M23_59_d N005_59 N005_59_M23_59_d 0.01
R_B_59_M23_59_g B_59 B_59_M23_59_g 0.01
R_N011_59_M23_59_s N011_59 N011_59_M23_59_s 0.01
M23_59 N005_59_M23_59_d B_59_M23_59_g N011_59_M23_59_s 0 nmos l=1u w=2u
R_N005_59_M24_59_d N005_59 N005_59_M24_59_d 0.01
R_C_59_M24_59_g C_59 C_59_M24_59_g 0.01
R_N009_59_M24_59_s N009_59 N009_59_M24_59_s 0.01
M24_59 N005_59_M24_59_d C_59_M24_59_g N009_59_M24_59_s 0 nmos l=1u w=2u
R_C_60_M25_59_d C_60 C_60_M25_59_d 0.01
R_N005_59_M25_59_g N005_59 N005_59_M25_59_g 0.01
M25_59 C_60_M25_59_d N005_59_M25_59_g 0 0 nmos l=1u w=1u
R_N002_59_M26_59_d N002_59 N002_59_M26_59_d 0.01
R_N005_59_M26_59_g N005_59 N005_59_M26_59_g 0.01
R_N007_59_M26_59_s N007_59 N007_59_M26_59_s 0.01
R_VDD_M26_59_b VDD VDD_M26_59_b 0.01
M26_59 N002_59_M26_59_d N005_59_M26_59_g N007_59_M26_59_s VDD_M26_59_b pmos l=1u w=4u
R_VDD_M27_59_d VDD VDD_M27_59_d 0.01
R_N007_59_M27_59_g N007_59 N007_59_M27_59_g 0.01
R_S_59_M27_59_s S_59 S_59_M27_59_s 0.01
R_VDD_M27_59_b VDD VDD_M27_59_b 0.01
M27_59 VDD_M27_59_d N007_59_M27_59_g S_59_M27_59_s VDD_M27_59_b pmos l=1u w=2u
R_S_59_M28_59_d S_59 S_59_M28_59_d 0.01
R_N007_59_M28_59_g N007_59 N007_59_M28_59_g 0.01
M28_59 S_59_M28_59_d N007_59_M28_59_g 0 0 nmos l=1u w=1u
C_S_59 S_59 0 1f
* --- Bit 60 ---
R_VDD_M1_60_d VDD VDD_M1_60_d 0.01
R_A_60_M1_60_g A_60 A_60_M1_60_g 0.01
R_N003_60_M1_60_s N003_60 N003_60_M1_60_s 0.01
R_VDD_M1_60_b VDD VDD_M1_60_b 0.01
M1_60 VDD_M1_60_d A_60_M1_60_g N003_60_M1_60_s VDD_M1_60_b pmos l=1u w=4u
R_N003_60_M2_60_d N003_60 N003_60_M2_60_d 0.01
R_B_60_M2_60_g B_60 B_60_M2_60_g 0.01
R_N005_60_M2_60_s N005_60 N005_60_M2_60_s 0.01
R_VDD_M2_60_b VDD VDD_M2_60_b 0.01
M2_60 N003_60_M2_60_d B_60_M2_60_g N005_60_M2_60_s VDD_M2_60_b pmos l=1u w=4u
R_VDD_M3_60_d VDD VDD_M3_60_d 0.01
R_A_60_M3_60_g A_60 A_60_M3_60_g 0.01
R_N001_60_M3_60_s N001_60 N001_60_M3_60_s 0.01
R_VDD_M3_60_b VDD VDD_M3_60_b 0.01
M3_60 VDD_M3_60_d A_60_M3_60_g N001_60_M3_60_s VDD_M3_60_b pmos l=1u w=4u
R_N001_60_M4_60_d N001_60 N001_60_M4_60_d 0.01
R_C_60_M4_60_g C_60 C_60_M4_60_g 0.01
R_N005_60_M4_60_s N005_60 N005_60_M4_60_s 0.01
R_VDD_M4_60_b VDD VDD_M4_60_b 0.01
M4_60 N001_60_M4_60_d C_60_M4_60_g N005_60_M4_60_s VDD_M4_60_b pmos l=1u w=4u
R_VDD_M5_60_d VDD VDD_M5_60_d 0.01
R_B_60_M5_60_g B_60 B_60_M5_60_g 0.01
R_N001_60_M5_60_s N001_60 N001_60_M5_60_s 0.01
R_VDD_M5_60_b VDD VDD_M5_60_b 0.01
M5_60 VDD_M5_60_d B_60_M5_60_g N001_60_M5_60_s VDD_M5_60_b pmos l=1u w=4u
R_VDD_M6_60_d VDD VDD_M6_60_d 0.01
R_N005_60_M6_60_g N005_60 N005_60_M6_60_g 0.01
R_C_61_M6_60_s C_61 C_61_M6_60_s 0.01
R_VDD_M6_60_b VDD VDD_M6_60_b 0.01
M6_60 VDD_M6_60_d N005_60_M6_60_g C_61_M6_60_s VDD_M6_60_b pmos l=1u w=2u
R_VDD_M7_60_d VDD VDD_M7_60_d 0.01
R_A_60_M7_60_g A_60 A_60_M7_60_g 0.01
R_N002_60_M7_60_s N002_60 N002_60_M7_60_s 0.01
R_VDD_M7_60_b VDD VDD_M7_60_b 0.01
M7_60 VDD_M7_60_d A_60_M7_60_g N002_60_M7_60_s VDD_M7_60_b pmos l=1u w=4u
R_VDD_M8_60_d VDD VDD_M8_60_d 0.01
R_B_60_M8_60_g B_60 B_60_M8_60_g 0.01
R_N002_60_M8_60_s N002_60 N002_60_M8_60_s 0.01
R_VDD_M8_60_b VDD VDD_M8_60_b 0.01
M8_60 VDD_M8_60_d B_60_M8_60_g N002_60_M8_60_s VDD_M8_60_b pmos l=1u w=4u
R_VDD_M9_60_d VDD VDD_M9_60_d 0.01
R_C_60_M9_60_g C_60 C_60_M9_60_g 0.01
R_N002_60_M9_60_s N002_60 N002_60_M9_60_s 0.01
R_VDD_M9_60_b VDD VDD_M9_60_b 0.01
M9_60 VDD_M9_60_d C_60_M9_60_g N002_60_M9_60_s VDD_M9_60_b pmos l=1u w=4u
R_VDD_M10_60_d VDD VDD_M10_60_d 0.01
R_A_60_M10_60_g A_60 A_60_M10_60_g 0.01
R_N004_60_M10_60_s N004_60 N004_60_M10_60_s 0.01
R_VDD_M10_60_b VDD VDD_M10_60_b 0.01
M10_60 VDD_M10_60_d A_60_M10_60_g N004_60_M10_60_s VDD_M10_60_b pmos l=1u w=8u
R_N004_60_M11_60_d N004_60 N004_60_M11_60_d 0.01
R_B_60_M11_60_g B_60 B_60_M11_60_g 0.01
R_N006_60_M11_60_s N006_60 N006_60_M11_60_s 0.01
R_VDD_M11_60_b VDD VDD_M11_60_b 0.01
M11_60 N004_60_M11_60_d B_60_M11_60_g N006_60_M11_60_s VDD_M11_60_b pmos l=1u w=8u
R_N006_60_M12_60_d N006_60 N006_60_M12_60_d 0.01
R_C_60_M12_60_g C_60 C_60_M12_60_g 0.01
R_N007_60_M12_60_s N007_60 N007_60_M12_60_s 0.01
R_VDD_M12_60_b VDD VDD_M12_60_b 0.01
M12_60 N006_60_M12_60_d C_60_M12_60_g N007_60_M12_60_s VDD_M12_60_b pmos l=1u w=8u
R_N007_60_M13_60_d N007_60 N007_60_M13_60_d 0.01
R_C_60_M13_60_g C_60 C_60_M13_60_g 0.01
R_N008_60_M13_60_s N008_60 N008_60_M13_60_s 0.01
M13_60 N007_60_M13_60_d C_60_M13_60_g N008_60_M13_60_s 0 nmos l=1u w=8u
R_N008_60_M14_60_d N008_60 N008_60_M14_60_d 0.01
R_B_60_M14_60_g B_60 B_60_M14_60_g 0.01
R_N012_60_M14_60_s N012_60 N012_60_M14_60_s 0.01
M14_60 N008_60_M14_60_d B_60_M14_60_g N012_60_M14_60_s 0 nmos l=1u w=8u
R_N012_60_M15_60_d N012_60 N012_60_M15_60_d 0.01
R_A_60_M15_60_g A_60 A_60_M15_60_g 0.01
M15_60 N012_60_M15_60_d A_60_M15_60_g 0 0 nmos l=1u w=8u
R_N010_60_M16_60_d N010_60 N010_60_M16_60_d 0.01
R_C_60_M16_60_g C_60 C_60_M16_60_g 0.01
M16_60 N010_60_M16_60_d C_60_M16_60_g 0 0 nmos l=1u w=2u
R_N010_60_M17_60_d N010_60 N010_60_M17_60_d 0.01
R_B_60_M17_60_g B_60 B_60_M17_60_g 0.01
M17_60 N010_60_M17_60_d B_60_M17_60_g 0 0 nmos l=1u w=2u
R_N010_60_M18_60_d N010_60 N010_60_M18_60_d 0.01
R_A_60_M18_60_g A_60 A_60_M18_60_g 0.01
M18_60 N010_60_M18_60_d A_60_M18_60_g 0 0 nmos l=1u w=2u
R_N007_60_M19_60_d N007_60 N007_60_M19_60_d 0.01
R_N005_60_M19_60_g N005_60 N005_60_M19_60_g 0.01
R_N010_60_M19_60_s N010_60 N010_60_M19_60_s 0.01
M19_60 N007_60_M19_60_d N005_60_M19_60_g N010_60_M19_60_s 0 nmos l=1u w=2u
R_N009_60_M20_60_d N009_60 N009_60_M20_60_d 0.01
R_B_60_M20_60_g B_60 B_60_M20_60_g 0.01
M20_60 N009_60_M20_60_d B_60_M20_60_g 0 0 nmos l=1u w=2u
R_N009_60_M21_60_d N009_60 N009_60_M21_60_d 0.01
R_A_60_M21_60_g A_60 A_60_M21_60_g 0.01
M21_60 N009_60_M21_60_d A_60_M21_60_g 0 0 nmos l=1u w=2u
R_N011_60_M22_60_d N011_60 N011_60_M22_60_d 0.01
R_A_60_M22_60_g A_60 A_60_M22_60_g 0.01
M22_60 N011_60_M22_60_d A_60_M22_60_g 0 0 nmos l=1u w=2u
R_N005_60_M23_60_d N005_60 N005_60_M23_60_d 0.01
R_B_60_M23_60_g B_60 B_60_M23_60_g 0.01
R_N011_60_M23_60_s N011_60 N011_60_M23_60_s 0.01
M23_60 N005_60_M23_60_d B_60_M23_60_g N011_60_M23_60_s 0 nmos l=1u w=2u
R_N005_60_M24_60_d N005_60 N005_60_M24_60_d 0.01
R_C_60_M24_60_g C_60 C_60_M24_60_g 0.01
R_N009_60_M24_60_s N009_60 N009_60_M24_60_s 0.01
M24_60 N005_60_M24_60_d C_60_M24_60_g N009_60_M24_60_s 0 nmos l=1u w=2u
R_C_61_M25_60_d C_61 C_61_M25_60_d 0.01
R_N005_60_M25_60_g N005_60 N005_60_M25_60_g 0.01
M25_60 C_61_M25_60_d N005_60_M25_60_g 0 0 nmos l=1u w=1u
R_N002_60_M26_60_d N002_60 N002_60_M26_60_d 0.01
R_N005_60_M26_60_g N005_60 N005_60_M26_60_g 0.01
R_N007_60_M26_60_s N007_60 N007_60_M26_60_s 0.01
R_VDD_M26_60_b VDD VDD_M26_60_b 0.01
M26_60 N002_60_M26_60_d N005_60_M26_60_g N007_60_M26_60_s VDD_M26_60_b pmos l=1u w=4u
R_VDD_M27_60_d VDD VDD_M27_60_d 0.01
R_N007_60_M27_60_g N007_60 N007_60_M27_60_g 0.01
R_S_60_M27_60_s S_60 S_60_M27_60_s 0.01
R_VDD_M27_60_b VDD VDD_M27_60_b 0.01
M27_60 VDD_M27_60_d N007_60_M27_60_g S_60_M27_60_s VDD_M27_60_b pmos l=1u w=2u
R_S_60_M28_60_d S_60 S_60_M28_60_d 0.01
R_N007_60_M28_60_g N007_60 N007_60_M28_60_g 0.01
M28_60 S_60_M28_60_d N007_60_M28_60_g 0 0 nmos l=1u w=1u
C_S_60 S_60 0 1f
* --- Bit 61 ---
R_VDD_M1_61_d VDD VDD_M1_61_d 0.01
R_A_61_M1_61_g A_61 A_61_M1_61_g 0.01
R_N003_61_M1_61_s N003_61 N003_61_M1_61_s 0.01
R_VDD_M1_61_b VDD VDD_M1_61_b 0.01
M1_61 VDD_M1_61_d A_61_M1_61_g N003_61_M1_61_s VDD_M1_61_b pmos l=1u w=4u
R_N003_61_M2_61_d N003_61 N003_61_M2_61_d 0.01
R_B_61_M2_61_g B_61 B_61_M2_61_g 0.01
R_N005_61_M2_61_s N005_61 N005_61_M2_61_s 0.01
R_VDD_M2_61_b VDD VDD_M2_61_b 0.01
M2_61 N003_61_M2_61_d B_61_M2_61_g N005_61_M2_61_s VDD_M2_61_b pmos l=1u w=4u
R_VDD_M3_61_d VDD VDD_M3_61_d 0.01
R_A_61_M3_61_g A_61 A_61_M3_61_g 0.01
R_N001_61_M3_61_s N001_61 N001_61_M3_61_s 0.01
R_VDD_M3_61_b VDD VDD_M3_61_b 0.01
M3_61 VDD_M3_61_d A_61_M3_61_g N001_61_M3_61_s VDD_M3_61_b pmos l=1u w=4u
R_N001_61_M4_61_d N001_61 N001_61_M4_61_d 0.01
R_C_61_M4_61_g C_61 C_61_M4_61_g 0.01
R_N005_61_M4_61_s N005_61 N005_61_M4_61_s 0.01
R_VDD_M4_61_b VDD VDD_M4_61_b 0.01
M4_61 N001_61_M4_61_d C_61_M4_61_g N005_61_M4_61_s VDD_M4_61_b pmos l=1u w=4u
R_VDD_M5_61_d VDD VDD_M5_61_d 0.01
R_B_61_M5_61_g B_61 B_61_M5_61_g 0.01
R_N001_61_M5_61_s N001_61 N001_61_M5_61_s 0.01
R_VDD_M5_61_b VDD VDD_M5_61_b 0.01
M5_61 VDD_M5_61_d B_61_M5_61_g N001_61_M5_61_s VDD_M5_61_b pmos l=1u w=4u
R_VDD_M6_61_d VDD VDD_M6_61_d 0.01
R_N005_61_M6_61_g N005_61 N005_61_M6_61_g 0.01
R_C_62_M6_61_s C_62 C_62_M6_61_s 0.01
R_VDD_M6_61_b VDD VDD_M6_61_b 0.01
M6_61 VDD_M6_61_d N005_61_M6_61_g C_62_M6_61_s VDD_M6_61_b pmos l=1u w=2u
R_VDD_M7_61_d VDD VDD_M7_61_d 0.01
R_A_61_M7_61_g A_61 A_61_M7_61_g 0.01
R_N002_61_M7_61_s N002_61 N002_61_M7_61_s 0.01
R_VDD_M7_61_b VDD VDD_M7_61_b 0.01
M7_61 VDD_M7_61_d A_61_M7_61_g N002_61_M7_61_s VDD_M7_61_b pmos l=1u w=4u
R_VDD_M8_61_d VDD VDD_M8_61_d 0.01
R_B_61_M8_61_g B_61 B_61_M8_61_g 0.01
R_N002_61_M8_61_s N002_61 N002_61_M8_61_s 0.01
R_VDD_M8_61_b VDD VDD_M8_61_b 0.01
M8_61 VDD_M8_61_d B_61_M8_61_g N002_61_M8_61_s VDD_M8_61_b pmos l=1u w=4u
R_VDD_M9_61_d VDD VDD_M9_61_d 0.01
R_C_61_M9_61_g C_61 C_61_M9_61_g 0.01
R_N002_61_M9_61_s N002_61 N002_61_M9_61_s 0.01
R_VDD_M9_61_b VDD VDD_M9_61_b 0.01
M9_61 VDD_M9_61_d C_61_M9_61_g N002_61_M9_61_s VDD_M9_61_b pmos l=1u w=4u
R_VDD_M10_61_d VDD VDD_M10_61_d 0.01
R_A_61_M10_61_g A_61 A_61_M10_61_g 0.01
R_N004_61_M10_61_s N004_61 N004_61_M10_61_s 0.01
R_VDD_M10_61_b VDD VDD_M10_61_b 0.01
M10_61 VDD_M10_61_d A_61_M10_61_g N004_61_M10_61_s VDD_M10_61_b pmos l=1u w=8u
R_N004_61_M11_61_d N004_61 N004_61_M11_61_d 0.01
R_B_61_M11_61_g B_61 B_61_M11_61_g 0.01
R_N006_61_M11_61_s N006_61 N006_61_M11_61_s 0.01
R_VDD_M11_61_b VDD VDD_M11_61_b 0.01
M11_61 N004_61_M11_61_d B_61_M11_61_g N006_61_M11_61_s VDD_M11_61_b pmos l=1u w=8u
R_N006_61_M12_61_d N006_61 N006_61_M12_61_d 0.01
R_C_61_M12_61_g C_61 C_61_M12_61_g 0.01
R_N007_61_M12_61_s N007_61 N007_61_M12_61_s 0.01
R_VDD_M12_61_b VDD VDD_M12_61_b 0.01
M12_61 N006_61_M12_61_d C_61_M12_61_g N007_61_M12_61_s VDD_M12_61_b pmos l=1u w=8u
R_N007_61_M13_61_d N007_61 N007_61_M13_61_d 0.01
R_C_61_M13_61_g C_61 C_61_M13_61_g 0.01
R_N008_61_M13_61_s N008_61 N008_61_M13_61_s 0.01
M13_61 N007_61_M13_61_d C_61_M13_61_g N008_61_M13_61_s 0 nmos l=1u w=8u
R_N008_61_M14_61_d N008_61 N008_61_M14_61_d 0.01
R_B_61_M14_61_g B_61 B_61_M14_61_g 0.01
R_N012_61_M14_61_s N012_61 N012_61_M14_61_s 0.01
M14_61 N008_61_M14_61_d B_61_M14_61_g N012_61_M14_61_s 0 nmos l=1u w=8u
R_N012_61_M15_61_d N012_61 N012_61_M15_61_d 0.01
R_A_61_M15_61_g A_61 A_61_M15_61_g 0.01
M15_61 N012_61_M15_61_d A_61_M15_61_g 0 0 nmos l=1u w=8u
R_N010_61_M16_61_d N010_61 N010_61_M16_61_d 0.01
R_C_61_M16_61_g C_61 C_61_M16_61_g 0.01
M16_61 N010_61_M16_61_d C_61_M16_61_g 0 0 nmos l=1u w=2u
R_N010_61_M17_61_d N010_61 N010_61_M17_61_d 0.01
R_B_61_M17_61_g B_61 B_61_M17_61_g 0.01
M17_61 N010_61_M17_61_d B_61_M17_61_g 0 0 nmos l=1u w=2u
R_N010_61_M18_61_d N010_61 N010_61_M18_61_d 0.01
R_A_61_M18_61_g A_61 A_61_M18_61_g 0.01
M18_61 N010_61_M18_61_d A_61_M18_61_g 0 0 nmos l=1u w=2u
R_N007_61_M19_61_d N007_61 N007_61_M19_61_d 0.01
R_N005_61_M19_61_g N005_61 N005_61_M19_61_g 0.01
R_N010_61_M19_61_s N010_61 N010_61_M19_61_s 0.01
M19_61 N007_61_M19_61_d N005_61_M19_61_g N010_61_M19_61_s 0 nmos l=1u w=2u
R_N009_61_M20_61_d N009_61 N009_61_M20_61_d 0.01
R_B_61_M20_61_g B_61 B_61_M20_61_g 0.01
M20_61 N009_61_M20_61_d B_61_M20_61_g 0 0 nmos l=1u w=2u
R_N009_61_M21_61_d N009_61 N009_61_M21_61_d 0.01
R_A_61_M21_61_g A_61 A_61_M21_61_g 0.01
M21_61 N009_61_M21_61_d A_61_M21_61_g 0 0 nmos l=1u w=2u
R_N011_61_M22_61_d N011_61 N011_61_M22_61_d 0.01
R_A_61_M22_61_g A_61 A_61_M22_61_g 0.01
M22_61 N011_61_M22_61_d A_61_M22_61_g 0 0 nmos l=1u w=2u
R_N005_61_M23_61_d N005_61 N005_61_M23_61_d 0.01
R_B_61_M23_61_g B_61 B_61_M23_61_g 0.01
R_N011_61_M23_61_s N011_61 N011_61_M23_61_s 0.01
M23_61 N005_61_M23_61_d B_61_M23_61_g N011_61_M23_61_s 0 nmos l=1u w=2u
R_N005_61_M24_61_d N005_61 N005_61_M24_61_d 0.01
R_C_61_M24_61_g C_61 C_61_M24_61_g 0.01
R_N009_61_M24_61_s N009_61 N009_61_M24_61_s 0.01
M24_61 N005_61_M24_61_d C_61_M24_61_g N009_61_M24_61_s 0 nmos l=1u w=2u
R_C_62_M25_61_d C_62 C_62_M25_61_d 0.01
R_N005_61_M25_61_g N005_61 N005_61_M25_61_g 0.01
M25_61 C_62_M25_61_d N005_61_M25_61_g 0 0 nmos l=1u w=1u
R_N002_61_M26_61_d N002_61 N002_61_M26_61_d 0.01
R_N005_61_M26_61_g N005_61 N005_61_M26_61_g 0.01
R_N007_61_M26_61_s N007_61 N007_61_M26_61_s 0.01
R_VDD_M26_61_b VDD VDD_M26_61_b 0.01
M26_61 N002_61_M26_61_d N005_61_M26_61_g N007_61_M26_61_s VDD_M26_61_b pmos l=1u w=4u
R_VDD_M27_61_d VDD VDD_M27_61_d 0.01
R_N007_61_M27_61_g N007_61 N007_61_M27_61_g 0.01
R_S_61_M27_61_s S_61 S_61_M27_61_s 0.01
R_VDD_M27_61_b VDD VDD_M27_61_b 0.01
M27_61 VDD_M27_61_d N007_61_M27_61_g S_61_M27_61_s VDD_M27_61_b pmos l=1u w=2u
R_S_61_M28_61_d S_61 S_61_M28_61_d 0.01
R_N007_61_M28_61_g N007_61 N007_61_M28_61_g 0.01
M28_61 S_61_M28_61_d N007_61_M28_61_g 0 0 nmos l=1u w=1u
C_S_61 S_61 0 1f
* --- Bit 62 ---
R_VDD_M1_62_d VDD VDD_M1_62_d 0.01
R_A_62_M1_62_g A_62 A_62_M1_62_g 0.01
R_N003_62_M1_62_s N003_62 N003_62_M1_62_s 0.01
R_VDD_M1_62_b VDD VDD_M1_62_b 0.01
M1_62 VDD_M1_62_d A_62_M1_62_g N003_62_M1_62_s VDD_M1_62_b pmos l=1u w=4u
R_N003_62_M2_62_d N003_62 N003_62_M2_62_d 0.01
R_B_62_M2_62_g B_62 B_62_M2_62_g 0.01
R_N005_62_M2_62_s N005_62 N005_62_M2_62_s 0.01
R_VDD_M2_62_b VDD VDD_M2_62_b 0.01
M2_62 N003_62_M2_62_d B_62_M2_62_g N005_62_M2_62_s VDD_M2_62_b pmos l=1u w=4u
R_VDD_M3_62_d VDD VDD_M3_62_d 0.01
R_A_62_M3_62_g A_62 A_62_M3_62_g 0.01
R_N001_62_M3_62_s N001_62 N001_62_M3_62_s 0.01
R_VDD_M3_62_b VDD VDD_M3_62_b 0.01
M3_62 VDD_M3_62_d A_62_M3_62_g N001_62_M3_62_s VDD_M3_62_b pmos l=1u w=4u
R_N001_62_M4_62_d N001_62 N001_62_M4_62_d 0.01
R_C_62_M4_62_g C_62 C_62_M4_62_g 0.01
R_N005_62_M4_62_s N005_62 N005_62_M4_62_s 0.01
R_VDD_M4_62_b VDD VDD_M4_62_b 0.01
M4_62 N001_62_M4_62_d C_62_M4_62_g N005_62_M4_62_s VDD_M4_62_b pmos l=1u w=4u
R_VDD_M5_62_d VDD VDD_M5_62_d 0.01
R_B_62_M5_62_g B_62 B_62_M5_62_g 0.01
R_N001_62_M5_62_s N001_62 N001_62_M5_62_s 0.01
R_VDD_M5_62_b VDD VDD_M5_62_b 0.01
M5_62 VDD_M5_62_d B_62_M5_62_g N001_62_M5_62_s VDD_M5_62_b pmos l=1u w=4u
R_VDD_M6_62_d VDD VDD_M6_62_d 0.01
R_N005_62_M6_62_g N005_62 N005_62_M6_62_g 0.01
R_C_63_M6_62_s C_63 C_63_M6_62_s 0.01
R_VDD_M6_62_b VDD VDD_M6_62_b 0.01
M6_62 VDD_M6_62_d N005_62_M6_62_g C_63_M6_62_s VDD_M6_62_b pmos l=1u w=2u
R_VDD_M7_62_d VDD VDD_M7_62_d 0.01
R_A_62_M7_62_g A_62 A_62_M7_62_g 0.01
R_N002_62_M7_62_s N002_62 N002_62_M7_62_s 0.01
R_VDD_M7_62_b VDD VDD_M7_62_b 0.01
M7_62 VDD_M7_62_d A_62_M7_62_g N002_62_M7_62_s VDD_M7_62_b pmos l=1u w=4u
R_VDD_M8_62_d VDD VDD_M8_62_d 0.01
R_B_62_M8_62_g B_62 B_62_M8_62_g 0.01
R_N002_62_M8_62_s N002_62 N002_62_M8_62_s 0.01
R_VDD_M8_62_b VDD VDD_M8_62_b 0.01
M8_62 VDD_M8_62_d B_62_M8_62_g N002_62_M8_62_s VDD_M8_62_b pmos l=1u w=4u
R_VDD_M9_62_d VDD VDD_M9_62_d 0.01
R_C_62_M9_62_g C_62 C_62_M9_62_g 0.01
R_N002_62_M9_62_s N002_62 N002_62_M9_62_s 0.01
R_VDD_M9_62_b VDD VDD_M9_62_b 0.01
M9_62 VDD_M9_62_d C_62_M9_62_g N002_62_M9_62_s VDD_M9_62_b pmos l=1u w=4u
R_VDD_M10_62_d VDD VDD_M10_62_d 0.01
R_A_62_M10_62_g A_62 A_62_M10_62_g 0.01
R_N004_62_M10_62_s N004_62 N004_62_M10_62_s 0.01
R_VDD_M10_62_b VDD VDD_M10_62_b 0.01
M10_62 VDD_M10_62_d A_62_M10_62_g N004_62_M10_62_s VDD_M10_62_b pmos l=1u w=8u
R_N004_62_M11_62_d N004_62 N004_62_M11_62_d 0.01
R_B_62_M11_62_g B_62 B_62_M11_62_g 0.01
R_N006_62_M11_62_s N006_62 N006_62_M11_62_s 0.01
R_VDD_M11_62_b VDD VDD_M11_62_b 0.01
M11_62 N004_62_M11_62_d B_62_M11_62_g N006_62_M11_62_s VDD_M11_62_b pmos l=1u w=8u
R_N006_62_M12_62_d N006_62 N006_62_M12_62_d 0.01
R_C_62_M12_62_g C_62 C_62_M12_62_g 0.01
R_N007_62_M12_62_s N007_62 N007_62_M12_62_s 0.01
R_VDD_M12_62_b VDD VDD_M12_62_b 0.01
M12_62 N006_62_M12_62_d C_62_M12_62_g N007_62_M12_62_s VDD_M12_62_b pmos l=1u w=8u
R_N007_62_M13_62_d N007_62 N007_62_M13_62_d 0.01
R_C_62_M13_62_g C_62 C_62_M13_62_g 0.01
R_N008_62_M13_62_s N008_62 N008_62_M13_62_s 0.01
M13_62 N007_62_M13_62_d C_62_M13_62_g N008_62_M13_62_s 0 nmos l=1u w=8u
R_N008_62_M14_62_d N008_62 N008_62_M14_62_d 0.01
R_B_62_M14_62_g B_62 B_62_M14_62_g 0.01
R_N012_62_M14_62_s N012_62 N012_62_M14_62_s 0.01
M14_62 N008_62_M14_62_d B_62_M14_62_g N012_62_M14_62_s 0 nmos l=1u w=8u
R_N012_62_M15_62_d N012_62 N012_62_M15_62_d 0.01
R_A_62_M15_62_g A_62 A_62_M15_62_g 0.01
M15_62 N012_62_M15_62_d A_62_M15_62_g 0 0 nmos l=1u w=8u
R_N010_62_M16_62_d N010_62 N010_62_M16_62_d 0.01
R_C_62_M16_62_g C_62 C_62_M16_62_g 0.01
M16_62 N010_62_M16_62_d C_62_M16_62_g 0 0 nmos l=1u w=2u
R_N010_62_M17_62_d N010_62 N010_62_M17_62_d 0.01
R_B_62_M17_62_g B_62 B_62_M17_62_g 0.01
M17_62 N010_62_M17_62_d B_62_M17_62_g 0 0 nmos l=1u w=2u
R_N010_62_M18_62_d N010_62 N010_62_M18_62_d 0.01
R_A_62_M18_62_g A_62 A_62_M18_62_g 0.01
M18_62 N010_62_M18_62_d A_62_M18_62_g 0 0 nmos l=1u w=2u
R_N007_62_M19_62_d N007_62 N007_62_M19_62_d 0.01
R_N005_62_M19_62_g N005_62 N005_62_M19_62_g 0.01
R_N010_62_M19_62_s N010_62 N010_62_M19_62_s 0.01
M19_62 N007_62_M19_62_d N005_62_M19_62_g N010_62_M19_62_s 0 nmos l=1u w=2u
R_N009_62_M20_62_d N009_62 N009_62_M20_62_d 0.01
R_B_62_M20_62_g B_62 B_62_M20_62_g 0.01
M20_62 N009_62_M20_62_d B_62_M20_62_g 0 0 nmos l=1u w=2u
R_N009_62_M21_62_d N009_62 N009_62_M21_62_d 0.01
R_A_62_M21_62_g A_62 A_62_M21_62_g 0.01
M21_62 N009_62_M21_62_d A_62_M21_62_g 0 0 nmos l=1u w=2u
R_N011_62_M22_62_d N011_62 N011_62_M22_62_d 0.01
R_A_62_M22_62_g A_62 A_62_M22_62_g 0.01
M22_62 N011_62_M22_62_d A_62_M22_62_g 0 0 nmos l=1u w=2u
R_N005_62_M23_62_d N005_62 N005_62_M23_62_d 0.01
R_B_62_M23_62_g B_62 B_62_M23_62_g 0.01
R_N011_62_M23_62_s N011_62 N011_62_M23_62_s 0.01
M23_62 N005_62_M23_62_d B_62_M23_62_g N011_62_M23_62_s 0 nmos l=1u w=2u
R_N005_62_M24_62_d N005_62 N005_62_M24_62_d 0.01
R_C_62_M24_62_g C_62 C_62_M24_62_g 0.01
R_N009_62_M24_62_s N009_62 N009_62_M24_62_s 0.01
M24_62 N005_62_M24_62_d C_62_M24_62_g N009_62_M24_62_s 0 nmos l=1u w=2u
R_C_63_M25_62_d C_63 C_63_M25_62_d 0.01
R_N005_62_M25_62_g N005_62 N005_62_M25_62_g 0.01
M25_62 C_63_M25_62_d N005_62_M25_62_g 0 0 nmos l=1u w=1u
R_N002_62_M26_62_d N002_62 N002_62_M26_62_d 0.01
R_N005_62_M26_62_g N005_62 N005_62_M26_62_g 0.01
R_N007_62_M26_62_s N007_62 N007_62_M26_62_s 0.01
R_VDD_M26_62_b VDD VDD_M26_62_b 0.01
M26_62 N002_62_M26_62_d N005_62_M26_62_g N007_62_M26_62_s VDD_M26_62_b pmos l=1u w=4u
R_VDD_M27_62_d VDD VDD_M27_62_d 0.01
R_N007_62_M27_62_g N007_62 N007_62_M27_62_g 0.01
R_S_62_M27_62_s S_62 S_62_M27_62_s 0.01
R_VDD_M27_62_b VDD VDD_M27_62_b 0.01
M27_62 VDD_M27_62_d N007_62_M27_62_g S_62_M27_62_s VDD_M27_62_b pmos l=1u w=2u
R_S_62_M28_62_d S_62 S_62_M28_62_d 0.01
R_N007_62_M28_62_g N007_62 N007_62_M28_62_g 0.01
M28_62 S_62_M28_62_d N007_62_M28_62_g 0 0 nmos l=1u w=1u
C_S_62 S_62 0 1f
* --- Bit 63 ---
R_VDD_M1_63_d VDD VDD_M1_63_d 0.01
R_A_63_M1_63_g A_63 A_63_M1_63_g 0.01
R_N003_63_M1_63_s N003_63 N003_63_M1_63_s 0.01
R_VDD_M1_63_b VDD VDD_M1_63_b 0.01
M1_63 VDD_M1_63_d A_63_M1_63_g N003_63_M1_63_s VDD_M1_63_b pmos l=1u w=4u
R_N003_63_M2_63_d N003_63 N003_63_M2_63_d 0.01
R_B_63_M2_63_g B_63 B_63_M2_63_g 0.01
R_N005_63_M2_63_s N005_63 N005_63_M2_63_s 0.01
R_VDD_M2_63_b VDD VDD_M2_63_b 0.01
M2_63 N003_63_M2_63_d B_63_M2_63_g N005_63_M2_63_s VDD_M2_63_b pmos l=1u w=4u
R_VDD_M3_63_d VDD VDD_M3_63_d 0.01
R_A_63_M3_63_g A_63 A_63_M3_63_g 0.01
R_N001_63_M3_63_s N001_63 N001_63_M3_63_s 0.01
R_VDD_M3_63_b VDD VDD_M3_63_b 0.01
M3_63 VDD_M3_63_d A_63_M3_63_g N001_63_M3_63_s VDD_M3_63_b pmos l=1u w=4u
R_N001_63_M4_63_d N001_63 N001_63_M4_63_d 0.01
R_C_63_M4_63_g C_63 C_63_M4_63_g 0.01
R_N005_63_M4_63_s N005_63 N005_63_M4_63_s 0.01
R_VDD_M4_63_b VDD VDD_M4_63_b 0.01
M4_63 N001_63_M4_63_d C_63_M4_63_g N005_63_M4_63_s VDD_M4_63_b pmos l=1u w=4u
R_VDD_M5_63_d VDD VDD_M5_63_d 0.01
R_B_63_M5_63_g B_63 B_63_M5_63_g 0.01
R_N001_63_M5_63_s N001_63 N001_63_M5_63_s 0.01
R_VDD_M5_63_b VDD VDD_M5_63_b 0.01
M5_63 VDD_M5_63_d B_63_M5_63_g N001_63_M5_63_s VDD_M5_63_b pmos l=1u w=4u
R_VDD_M6_63_d VDD VDD_M6_63_d 0.01
R_N005_63_M6_63_g N005_63 N005_63_M6_63_g 0.01
R_C_64_M6_63_s C_64 C_64_M6_63_s 0.01
R_VDD_M6_63_b VDD VDD_M6_63_b 0.01
M6_63 VDD_M6_63_d N005_63_M6_63_g C_64_M6_63_s VDD_M6_63_b pmos l=1u w=2u
R_VDD_M7_63_d VDD VDD_M7_63_d 0.01
R_A_63_M7_63_g A_63 A_63_M7_63_g 0.01
R_N002_63_M7_63_s N002_63 N002_63_M7_63_s 0.01
R_VDD_M7_63_b VDD VDD_M7_63_b 0.01
M7_63 VDD_M7_63_d A_63_M7_63_g N002_63_M7_63_s VDD_M7_63_b pmos l=1u w=4u
R_VDD_M8_63_d VDD VDD_M8_63_d 0.01
R_B_63_M8_63_g B_63 B_63_M8_63_g 0.01
R_N002_63_M8_63_s N002_63 N002_63_M8_63_s 0.01
R_VDD_M8_63_b VDD VDD_M8_63_b 0.01
M8_63 VDD_M8_63_d B_63_M8_63_g N002_63_M8_63_s VDD_M8_63_b pmos l=1u w=4u
R_VDD_M9_63_d VDD VDD_M9_63_d 0.01
R_C_63_M9_63_g C_63 C_63_M9_63_g 0.01
R_N002_63_M9_63_s N002_63 N002_63_M9_63_s 0.01
R_VDD_M9_63_b VDD VDD_M9_63_b 0.01
M9_63 VDD_M9_63_d C_63_M9_63_g N002_63_M9_63_s VDD_M9_63_b pmos l=1u w=4u
R_VDD_M10_63_d VDD VDD_M10_63_d 0.01
R_A_63_M10_63_g A_63 A_63_M10_63_g 0.01
R_N004_63_M10_63_s N004_63 N004_63_M10_63_s 0.01
R_VDD_M10_63_b VDD VDD_M10_63_b 0.01
M10_63 VDD_M10_63_d A_63_M10_63_g N004_63_M10_63_s VDD_M10_63_b pmos l=1u w=8u
R_N004_63_M11_63_d N004_63 N004_63_M11_63_d 0.01
R_B_63_M11_63_g B_63 B_63_M11_63_g 0.01
R_N006_63_M11_63_s N006_63 N006_63_M11_63_s 0.01
R_VDD_M11_63_b VDD VDD_M11_63_b 0.01
M11_63 N004_63_M11_63_d B_63_M11_63_g N006_63_M11_63_s VDD_M11_63_b pmos l=1u w=8u
R_N006_63_M12_63_d N006_63 N006_63_M12_63_d 0.01
R_C_63_M12_63_g C_63 C_63_M12_63_g 0.01
R_N007_63_M12_63_s N007_63 N007_63_M12_63_s 0.01
R_VDD_M12_63_b VDD VDD_M12_63_b 0.01
M12_63 N006_63_M12_63_d C_63_M12_63_g N007_63_M12_63_s VDD_M12_63_b pmos l=1u w=8u
R_N007_63_M13_63_d N007_63 N007_63_M13_63_d 0.01
R_C_63_M13_63_g C_63 C_63_M13_63_g 0.01
R_N008_63_M13_63_s N008_63 N008_63_M13_63_s 0.01
M13_63 N007_63_M13_63_d C_63_M13_63_g N008_63_M13_63_s 0 nmos l=1u w=8u
R_N008_63_M14_63_d N008_63 N008_63_M14_63_d 0.01
R_B_63_M14_63_g B_63 B_63_M14_63_g 0.01
R_N012_63_M14_63_s N012_63 N012_63_M14_63_s 0.01
M14_63 N008_63_M14_63_d B_63_M14_63_g N012_63_M14_63_s 0 nmos l=1u w=8u
R_N012_63_M15_63_d N012_63 N012_63_M15_63_d 0.01
R_A_63_M15_63_g A_63 A_63_M15_63_g 0.01
M15_63 N012_63_M15_63_d A_63_M15_63_g 0 0 nmos l=1u w=8u
R_N010_63_M16_63_d N010_63 N010_63_M16_63_d 0.01
R_C_63_M16_63_g C_63 C_63_M16_63_g 0.01
M16_63 N010_63_M16_63_d C_63_M16_63_g 0 0 nmos l=1u w=2u
R_N010_63_M17_63_d N010_63 N010_63_M17_63_d 0.01
R_B_63_M17_63_g B_63 B_63_M17_63_g 0.01
M17_63 N010_63_M17_63_d B_63_M17_63_g 0 0 nmos l=1u w=2u
R_N010_63_M18_63_d N010_63 N010_63_M18_63_d 0.01
R_A_63_M18_63_g A_63 A_63_M18_63_g 0.01
M18_63 N010_63_M18_63_d A_63_M18_63_g 0 0 nmos l=1u w=2u
R_N007_63_M19_63_d N007_63 N007_63_M19_63_d 0.01
R_N005_63_M19_63_g N005_63 N005_63_M19_63_g 0.01
R_N010_63_M19_63_s N010_63 N010_63_M19_63_s 0.01
M19_63 N007_63_M19_63_d N005_63_M19_63_g N010_63_M19_63_s 0 nmos l=1u w=2u
R_N009_63_M20_63_d N009_63 N009_63_M20_63_d 0.01
R_B_63_M20_63_g B_63 B_63_M20_63_g 0.01
M20_63 N009_63_M20_63_d B_63_M20_63_g 0 0 nmos l=1u w=2u
R_N009_63_M21_63_d N009_63 N009_63_M21_63_d 0.01
R_A_63_M21_63_g A_63 A_63_M21_63_g 0.01
M21_63 N009_63_M21_63_d A_63_M21_63_g 0 0 nmos l=1u w=2u
R_N011_63_M22_63_d N011_63 N011_63_M22_63_d 0.01
R_A_63_M22_63_g A_63 A_63_M22_63_g 0.01
M22_63 N011_63_M22_63_d A_63_M22_63_g 0 0 nmos l=1u w=2u
R_N005_63_M23_63_d N005_63 N005_63_M23_63_d 0.01
R_B_63_M23_63_g B_63 B_63_M23_63_g 0.01
R_N011_63_M23_63_s N011_63 N011_63_M23_63_s 0.01
M23_63 N005_63_M23_63_d B_63_M23_63_g N011_63_M23_63_s 0 nmos l=1u w=2u
R_N005_63_M24_63_d N005_63 N005_63_M24_63_d 0.01
R_C_63_M24_63_g C_63 C_63_M24_63_g 0.01
R_N009_63_M24_63_s N009_63 N009_63_M24_63_s 0.01
M24_63 N005_63_M24_63_d C_63_M24_63_g N009_63_M24_63_s 0 nmos l=1u w=2u
R_C_64_M25_63_d C_64 C_64_M25_63_d 0.01
R_N005_63_M25_63_g N005_63 N005_63_M25_63_g 0.01
M25_63 C_64_M25_63_d N005_63_M25_63_g 0 0 nmos l=1u w=1u
R_N002_63_M26_63_d N002_63 N002_63_M26_63_d 0.01
R_N005_63_M26_63_g N005_63 N005_63_M26_63_g 0.01
R_N007_63_M26_63_s N007_63 N007_63_M26_63_s 0.01
R_VDD_M26_63_b VDD VDD_M26_63_b 0.01
M26_63 N002_63_M26_63_d N005_63_M26_63_g N007_63_M26_63_s VDD_M26_63_b pmos l=1u w=4u
R_VDD_M27_63_d VDD VDD_M27_63_d 0.01
R_N007_63_M27_63_g N007_63 N007_63_M27_63_g 0.01
R_S_63_M27_63_s S_63 S_63_M27_63_s 0.01
R_VDD_M27_63_b VDD VDD_M27_63_b 0.01
M27_63 VDD_M27_63_d N007_63_M27_63_g S_63_M27_63_s VDD_M27_63_b pmos l=1u w=2u
R_S_63_M28_63_d S_63 S_63_M28_63_d 0.01
R_N007_63_M28_63_g N007_63 N007_63_M28_63_g 0.01
M28_63 S_63_M28_63_d N007_63_M28_63_g 0 0 nmos l=1u w=1u
C_S_63 S_63 0 1f
C_Co_Final C_64 0 1p
C_Sum_Final S_63 0 1p

* --- Sources ---
V_VDD VDD 0 1.8
V_A_0 A_0 0 0
V_B_0 B_0 0 1.8
V_C_0 C_0 0 0
* Grounding inputs for bits 1-63 to prevent floating nodes
V_A_1 A_1 0 1.8
V_B_1 B_1 0 0
V_A_2 A_2 0 0
V_B_2 B_2 0 1.8
V_A_3 A_3 0 0
V_B_3 B_3 0 0
V_A_4 A_4 0 0
V_B_4 B_4 0 0
V_A_5 A_5 0 0
V_B_5 B_5 0 0
V_A_6 A_6 0 0
V_B_6 B_6 0 1.8
V_A_7 A_7 0 1.8
V_B_7 B_7 0 1.8
V_A_8 A_8 0 0
V_B_8 B_8 0 1.8
V_A_9 A_9 0 0
V_B_9 B_9 0 0
V_A_10 A_10 0 0
V_B_10 B_10 0 0
V_A_11 A_11 0 0
V_B_11 B_11 0 1.8
V_A_12 A_12 0 0
V_B_12 B_12 0 0
V_A_13 A_13 0 0
V_B_13 B_13 0 1.8
V_A_14 A_14 0 0
V_B_14 B_14 0 1.8
V_A_15 A_15 0 1.8
V_B_15 B_15 0 1.8
V_A_16 A_16 0 0
V_B_16 B_16 0 0
V_A_17 A_17 0 1.8
V_B_17 B_17 0 1.8
V_A_18 A_18 0 1.8
V_B_18 B_18 0 0
V_A_19 A_19 0 0
V_B_19 B_19 0 0
V_A_20 A_20 0 0
V_B_20 B_20 0 1.8
V_A_21 A_21 0 1.8
V_B_21 B_21 0 1.8
V_A_22 A_22 0 1.8
V_B_22 B_22 0 1.8
V_A_23 A_23 0 1.8
V_B_23 B_23 0 1.8
V_A_24 A_24 0 0
V_B_24 B_24 0 0
V_A_25 A_25 0 0
V_B_25 B_25 0 0
V_A_26 A_26 0 1.8
V_B_26 B_26 0 1.8
V_A_27 A_27 0 0
V_B_27 B_27 0 0
V_A_28 A_28 0 0
V_B_28 B_28 0 0
V_A_29 A_29 0 1.8
V_B_29 B_29 0 0
V_A_30 A_30 0 0
V_B_30 B_30 0 0
V_A_31 A_31 0 1.8
V_B_31 B_31 0 0
V_A_32 A_32 0 1.8
V_B_32 B_32 0 1.8
V_A_33 A_33 0 1.8
V_B_33 B_33 0 0
V_A_34 A_34 0 0
V_B_34 B_34 0 1.8
V_A_35 A_35 0 1.8
V_B_35 B_35 0 1.8
V_A_36 A_36 0 0
V_B_36 B_36 0 1.8
V_A_37 A_37 0 1.8
V_B_37 B_37 0 1.8
V_A_38 A_38 0 0
V_B_38 B_38 0 0
V_A_39 A_39 0 1.8
V_B_39 B_39 0 0
V_A_40 A_40 0 1.8
V_B_40 B_40 0 1.8
V_A_41 A_41 0 0
V_B_41 B_41 0 1.8
V_A_42 A_42 0 0
V_B_42 B_42 0 0
V_A_43 A_43 0 0
V_B_43 B_43 0 1.8
V_A_44 A_44 0 0
V_B_44 B_44 0 1.8
V_A_45 A_45 0 1.8
V_B_45 B_45 0 0
V_A_46 A_46 0 0
V_B_46 B_46 0 1.8
V_A_47 A_47 0 0
V_B_47 B_47 0 0
V_A_48 A_48 0 0
V_B_48 B_48 0 1.8
V_A_49 A_49 0 1.8
V_B_49 B_49 0 0
V_A_50 A_50 0 1.8
V_B_50 B_50 0 0
V_A_51 A_51 0 1.8
V_B_51 B_51 0 1.8
V_A_52 A_52 0 1.8
V_B_52 B_52 0 0
V_A_53 A_53 0 0
V_B_53 B_53 0 0
V_A_54 A_54 0 1.8
V_B_54 B_54 0 1.8
V_A_55 A_55 0 1.8
V_B_55 B_55 0 0
V_A_56 A_56 0 0
V_B_56 B_56 0 0
V_A_57 A_57 0 1.8
V_B_57 B_57 0 1.8
V_A_58 A_58 0 0
V_B_58 B_58 0 1.8
V_A_59 A_59 0 0
V_B_59 B_59 0 0
V_A_60 A_60 0 0
V_B_60 B_60 0 0
V_A_61 A_61 0 0
V_B_61 B_61 0 1.8
V_A_62 A_62 0 1.8
V_B_62 B_62 0 1.8
V_A_63 A_63 0 1.8
V_B_63 B_63 0 0

.tran 2u 50000u
.end
