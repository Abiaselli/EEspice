.title Basic amp optimised (rev-22)
.include '/home/boris/github/EEspice/Netlist/modelcards/ptm_90.txt'
*.param Vcm = 0.6
M3 d3 in2 midp vdd pmos W=70u  L=700n
M4 d4 in1 midp vdd pmos W=70u  L=700n
M6 midp bias1 vdd vdd pmos W=70u  L=1.4u
M1 d1 in1 midn 0 nmos W=32u  L=500n
M2 d2 in2 midn 0 nmos W=32u  L=500n
M5 midn bias2 0 0 nmos W=5u   L=1.4u
M7 d1  g7  vdd vdd pmos W=16u  L=350n
M8 d2  g7  vdd vdd pmos W=16u  L=350n
M9 g7  bias3 d1 vdd pmos W=16u  L=350n
M10 d10 bias3 d2 vdd pmos W=16u  L=350n
M15 g7  bias5 s15 0   nmos W=8u   L=240n
M16 s15 bias6 g7  vdd pmos W=16u  L=200n
M17 d10 bias5 s17 0   nmos W=8u   L=240n
M18 s17 bias6 d10 vdd pmos W=16u  L=200n
M11 s15 bias4 d4 0   nmos W=2u   L=360n
M12 s17 bias4 d3 0   nmos W=2u   L=360n
M13 d4  s15 0 0 nmos W=2u  L=180n
M14 d3  s15 0 0 nmos W=2u  L=180n
M19 out d10 vdd vdd pmos W=280u L=220n
M20 out s17 0   0   nmos W=140u L=220n
Cc1 out d10 10p
Cc2 out s17 10p
Cl  out 0 10p
Rl  out 0 1k
vbias1 bias1 0 DC 0.4
vbias2 bias2 0 DC 0.95
vbias3 bias3 0 DC 0.35
vbias4 bias4 0 DC 0.8
vbias5 bias5 0 DC 1.18
vbias6 bias6 0 DC 0.11
vdd  vdd 0 1.2
Vcm  cm  0  DC 0.6
Eidp cm in1 diffin 0  1
Eidn cm in2 diffin 0 -1
Vid  diffin 0 SIN (0 1u 10k 0 0 0)
.tran 50n 5000u
.end
