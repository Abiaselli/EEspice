Delay
.model nmos nmos (level=14 version=4.8.2)
.model pmos pmos (level=14 version=4.8.2)
* Simulation flags
.options acct
.options num_threads=2
.sparse
M1 output input VDD VDD pmos W=1u L=0.09u
M2 output input GND GND nmos W=1u L=0.09u
M3 net-3 output VDD VDD pmos W=1u L=0.09u
M4 net-3 output GND GND nmos W=1u L=0.09u
V8 input GND PULSE (0 1.8 40p 5p 5p 100p 200p)
V9 VDD GND 1.8
.tran 0.1p 200p

.end
