AC test for bsim4

.model nmos nmos (level=14 version=4.8.2)
.output Results/ac_bsim.raw

Vin gate 0 AC 1 0
M1 drain gate 0 0 nmos W=10u L=1u
R1 0 drain 1k

.ac dec 10 1 100G
.end
