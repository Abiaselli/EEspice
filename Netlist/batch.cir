batch test

.model nmos nmos (level=14 version=4.8.2)

m1 d g 0 0 nmos W=[100:10:200]u L=0.9u

Vds d 0 1
Vg g 0 3

.dc Vg 0 5 0.1
