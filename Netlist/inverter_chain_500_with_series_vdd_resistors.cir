* 1000inv

* Models
.model nmos nmos (level=14 version=4.8.2)
.model pmos pmos (level=14 version=4.8.2)

* Simulation flags
.options acct
.options num_threads=8

V1 VDD 0 1.8
V2 Vin 0 1

R1 VDD N001 0.001
M1 N001 Vin N051 N001 pmos l=0.9u w=10u
M2 N051 Vin 0 0 nmos l=0.9u w=10u
R2 VDD N002 0.001
M3 N002 N051 N052 N002 pmos l=0.9u w=10u
M4 N052 N051 0 0 nmos l=0.9u w=10u
R3 VDD N003 0.001
M5 N003 N052 N053 N003 pmos l=0.9u w=10u
M6 N053 N052 0 0 nmos l=0.9u w=10u
R4 VDD N004 0.001
M7 N004 N053 N054 N004 pmos l=0.9u w=10u
M8 N054 N053 0 0 nmos l=0.9u w=10u
R5 VDD N005 0.001
M9 N005 N054 N055 N005 pmos l=0.9u w=10u
M10 N055 N054 0 0 nmos l=0.9u w=10u
R6 VDD N006 0.001
M11 N006 N055 N056 N006 pmos l=0.9u w=10u
M12 N056 N055 0 0 nmos l=0.9u w=10u
R7 VDD N007 0.001
M13 N007 N056 N057 N007 pmos l=0.9u w=10u
M14 N057 N056 0 0 nmos l=0.9u w=10u
R8 VDD N008 0.001
M15 N008 N057 N058 N008 pmos l=0.9u w=10u
M16 N058 N057 0 0 nmos l=0.9u w=10u
R9 VDD N009 0.001
M17 N009 N058 N059 N009 pmos l=0.9u w=10u
M18 N059 N058 0 0 nmos l=0.9u w=10u
R10 VDD N010 0.001
M19 N010 N059 N060 N010 pmos l=0.9u w=10u
M20 N060 N059 0 0 nmos l=0.9u w=10u
R11 VDD N011 0.001
M21 N011 N060 N061 N011 pmos l=0.9u w=10u
M22 N061 N060 0 0 nmos l=0.9u w=10u
R12 VDD N012 0.001
M23 N012 N061 N062 N012 pmos l=0.9u w=10u
M24 N062 N061 0 0 nmos l=0.9u w=10u
R13 VDD N013 0.001
M25 N013 N062 N063 N013 pmos l=0.9u w=10u
M26 N063 N062 0 0 nmos l=0.9u w=10u
R14 VDD N014 0.001
M27 N014 N063 N064 N014 pmos l=0.9u w=10u
M28 N064 N063 0 0 nmos l=0.9u w=10u
R15 VDD N015 0.001
M29 N015 N064 N065 N015 pmos l=0.9u w=10u
M30 N065 N064 0 0 nmos l=0.9u w=10u
R16 VDD N016 0.001
M31 N016 N065 N066 N016 pmos l=0.9u w=10u
M32 N066 N065 0 0 nmos l=0.9u w=10u
R17 VDD N017 0.001
M33 N017 N066 N067 N017 pmos l=0.9u w=10u
M34 N067 N066 0 0 nmos l=0.9u w=10u
R18 VDD N018 0.001
M35 N018 N067 N068 N018 pmos l=0.9u w=10u
M36 N068 N067 0 0 nmos l=0.9u w=10u
R19 VDD N019 0.001
M37 N019 N068 N069 N019 pmos l=0.9u w=10u
M38 N069 N068 0 0 nmos l=0.9u w=10u
R20 VDD N020 0.001
M39 N020 N069 N070 N020 pmos l=0.9u w=10u
M40 N070 N069 0 0 nmos l=0.9u w=10u
R21 VDD N021 0.001
M41 N021 N070 N071 N021 pmos l=0.9u w=10u
M42 N071 N070 0 0 nmos l=0.9u w=10u
R22 VDD N022 0.001
M43 N022 N071 N072 N022 pmos l=0.9u w=10u
M44 N072 N071 0 0 nmos l=0.9u w=10u
R23 VDD N023 0.001
M45 N023 N072 N073 N023 pmos l=0.9u w=10u
M46 N073 N072 0 0 nmos l=0.9u w=10u
R24 VDD N024 0.001
M47 N024 N073 N074 N024 pmos l=0.9u w=10u
M48 N074 N073 0 0 nmos l=0.9u w=10u
R25 VDD N025 0.001
M49 N025 N074 N075 N025 pmos l=0.9u w=10u
M50 N075 N074 0 0 nmos l=0.9u w=10u
R26 VDD N026 0.001
M51 N026 N075 N076 N026 pmos l=0.9u w=10u
M52 N076 N075 0 0 nmos l=0.9u w=10u
R27 VDD N027 0.001
M53 N027 N076 N077 N027 pmos l=0.9u w=10u
M54 N077 N076 0 0 nmos l=0.9u w=10u
R28 VDD N028 0.001
M55 N028 N077 N078 N028 pmos l=0.9u w=10u
M56 N078 N077 0 0 nmos l=0.9u w=10u
R29 VDD N029 0.001
M57 N029 N078 N079 N029 pmos l=0.9u w=10u
M58 N079 N078 0 0 nmos l=0.9u w=10u
R30 VDD N030 0.001
M59 N030 N079 N080 N030 pmos l=0.9u w=10u
M60 N080 N079 0 0 nmos l=0.9u w=10u
R31 VDD N031 0.001
M61 N031 N080 N081 N031 pmos l=0.9u w=10u
M62 N081 N080 0 0 nmos l=0.9u w=10u
R32 VDD N032 0.001
M63 N032 N081 N082 N032 pmos l=0.9u w=10u
M64 N082 N081 0 0 nmos l=0.9u w=10u
R33 VDD N033 0.001
M65 N033 N082 N083 N033 pmos l=0.9u w=10u
M66 N083 N082 0 0 nmos l=0.9u w=10u
R34 VDD N034 0.001
M67 N034 N083 N084 N034 pmos l=0.9u w=10u
M68 N084 N083 0 0 nmos l=0.9u w=10u
R35 VDD N035 0.001
M69 N035 N084 N085 N035 pmos l=0.9u w=10u
M70 N085 N084 0 0 nmos l=0.9u w=10u
R36 VDD N036 0.001
M71 N036 N085 N086 N036 pmos l=0.9u w=10u
M72 N086 N085 0 0 nmos l=0.9u w=10u
R37 VDD N037 0.001
M73 N037 N086 N087 N037 pmos l=0.9u w=10u
M74 N087 N086 0 0 nmos l=0.9u w=10u
R38 VDD N038 0.001
M75 N038 N087 N088 N038 pmos l=0.9u w=10u
M76 N088 N087 0 0 nmos l=0.9u w=10u
R39 VDD N039 0.001
M77 N039 N088 N089 N039 pmos l=0.9u w=10u
M78 N089 N088 0 0 nmos l=0.9u w=10u
R40 VDD N040 0.001
M79 N040 N089 N090 N040 pmos l=0.9u w=10u
M80 N090 N089 0 0 nmos l=0.9u w=10u
R41 VDD N041 0.001
M81 N041 N090 N091 N041 pmos l=0.9u w=10u
M82 N091 N090 0 0 nmos l=0.9u w=10u
R42 VDD N042 0.001
M83 N042 N091 N092 N042 pmos l=0.9u w=10u
M84 N092 N091 0 0 nmos l=0.9u w=10u
R43 VDD N043 0.001
M85 N043 N092 N093 N043 pmos l=0.9u w=10u
M86 N093 N092 0 0 nmos l=0.9u w=10u
R44 VDD N044 0.001
M87 N044 N093 N094 N044 pmos l=0.9u w=10u
M88 N094 N093 0 0 nmos l=0.9u w=10u
R45 VDD N045 0.001
M89 N045 N094 N095 N045 pmos l=0.9u w=10u
M90 N095 N094 0 0 nmos l=0.9u w=10u
R46 VDD N046 0.001
M91 N046 N095 N096 N046 pmos l=0.9u w=10u
M92 N096 N095 0 0 nmos l=0.9u w=10u
R47 VDD N047 0.001
M93 N047 N096 N097 N047 pmos l=0.9u w=10u
M94 N097 N096 0 0 nmos l=0.9u w=10u
R48 VDD N048 0.001
M95 N048 N097 N098 N048 pmos l=0.9u w=10u
M96 N098 N097 0 0 nmos l=0.9u w=10u
R49 VDD N049 0.001
M97 N049 N098 N099 N049 pmos l=0.9u w=10u
M98 N099 N098 0 0 nmos l=0.9u w=10u
R50 VDD N050 0.001
M99 N050 N099 vout1 N050 pmos l=0.9u w=10u
M100 vout1 N099 0 0 nmos l=0.9u w=10u
R51 VDD N100 0.001
M101 N100 vout1 N150 N100 pmos l=0.9u w=10u
M102 N150 vout1 0 0 nmos l=0.9u w=10u
R52 VDD N101 0.001
M103 N101 N150 N151 N101 pmos l=0.9u w=10u
M104 N151 N150 0 0 nmos l=0.9u w=10u
R53 VDD N102 0.001
M105 N102 N151 N152 N102 pmos l=0.9u w=10u
M106 N152 N151 0 0 nmos l=0.9u w=10u
R54 VDD N103 0.001
M107 N103 N152 N153 N103 pmos l=0.9u w=10u
M108 N153 N152 0 0 nmos l=0.9u w=10u
R55 VDD N104 0.001
M109 N104 N153 N154 N104 pmos l=0.9u w=10u
M110 N154 N153 0 0 nmos l=0.9u w=10u
R56 VDD N105 0.001
M111 N105 N154 N155 N105 pmos l=0.9u w=10u
M112 N155 N154 0 0 nmos l=0.9u w=10u
R57 VDD N106 0.001
M113 N106 N155 N156 N106 pmos l=0.9u w=10u
M114 N156 N155 0 0 nmos l=0.9u w=10u
R58 VDD N107 0.001
M115 N107 N156 N157 N107 pmos l=0.9u w=10u
M116 N157 N156 0 0 nmos l=0.9u w=10u
R59 VDD N108 0.001
M117 N108 N157 N158 N108 pmos l=0.9u w=10u
M118 N158 N157 0 0 nmos l=0.9u w=10u
R60 VDD N109 0.001
M119 N109 N158 N159 N109 pmos l=0.9u w=10u
M120 N159 N158 0 0 nmos l=0.9u w=10u
R61 VDD N110 0.001
M121 N110 N159 N160 N110 pmos l=0.9u w=10u
M122 N160 N159 0 0 nmos l=0.9u w=10u
R62 VDD N111 0.001
M123 N111 N160 N161 N111 pmos l=0.9u w=10u
M124 N161 N160 0 0 nmos l=0.9u w=10u
R63 VDD N112 0.001
M125 N112 N161 N162 N112 pmos l=0.9u w=10u
M126 N162 N161 0 0 nmos l=0.9u w=10u
R64 VDD N113 0.001
M127 N113 N162 N163 N113 pmos l=0.9u w=10u
M128 N163 N162 0 0 nmos l=0.9u w=10u
R65 VDD N114 0.001
M129 N114 N163 N164 N114 pmos l=0.9u w=10u
M130 N164 N163 0 0 nmos l=0.9u w=10u
R66 VDD N115 0.001
M131 N115 N164 N165 N115 pmos l=0.9u w=10u
M132 N165 N164 0 0 nmos l=0.9u w=10u
R67 VDD N116 0.001
M133 N116 N165 N166 N116 pmos l=0.9u w=10u
M134 N166 N165 0 0 nmos l=0.9u w=10u
R68 VDD N117 0.001
M135 N117 N166 N167 N117 pmos l=0.9u w=10u
M136 N167 N166 0 0 nmos l=0.9u w=10u
R69 VDD N118 0.001
M137 N118 N167 N168 N118 pmos l=0.9u w=10u
M138 N168 N167 0 0 nmos l=0.9u w=10u
R70 VDD N119 0.001
M139 N119 N168 N169 N119 pmos l=0.9u w=10u
M140 N169 N168 0 0 nmos l=0.9u w=10u
R71 VDD N120 0.001
M141 N120 N169 N170 N120 pmos l=0.9u w=10u
M142 N170 N169 0 0 nmos l=0.9u w=10u
R72 VDD N121 0.001
M143 N121 N170 N171 N121 pmos l=0.9u w=10u
M144 N171 N170 0 0 nmos l=0.9u w=10u
R73 VDD N122 0.001
M145 N122 N171 N172 N122 pmos l=0.9u w=10u
M146 N172 N171 0 0 nmos l=0.9u w=10u
R74 VDD N123 0.001
M147 N123 N172 N173 N123 pmos l=0.9u w=10u
M148 N173 N172 0 0 nmos l=0.9u w=10u
R75 VDD N124 0.001
M149 N124 N173 N174 N124 pmos l=0.9u w=10u
M150 N174 N173 0 0 nmos l=0.9u w=10u
R76 VDD N125 0.001
M151 N125 N174 N175 N125 pmos l=0.9u w=10u
M152 N175 N174 0 0 nmos l=0.9u w=10u
R77 VDD N126 0.001
M153 N126 N175 N176 N126 pmos l=0.9u w=10u
M154 N176 N175 0 0 nmos l=0.9u w=10u
R78 VDD N127 0.001
M155 N127 N176 N177 N127 pmos l=0.9u w=10u
M156 N177 N176 0 0 nmos l=0.9u w=10u
R79 VDD N128 0.001
M157 N128 N177 N178 N128 pmos l=0.9u w=10u
M158 N178 N177 0 0 nmos l=0.9u w=10u
R80 VDD N129 0.001
M159 N129 N178 N179 N129 pmos l=0.9u w=10u
M160 N179 N178 0 0 nmos l=0.9u w=10u
R81 VDD N130 0.001
M161 N130 N179 N180 N130 pmos l=0.9u w=10u
M162 N180 N179 0 0 nmos l=0.9u w=10u
R82 VDD N131 0.001
M163 N131 N180 N181 N131 pmos l=0.9u w=10u
M164 N181 N180 0 0 nmos l=0.9u w=10u
R83 VDD N132 0.001
M165 N132 N181 N182 N132 pmos l=0.9u w=10u
M166 N182 N181 0 0 nmos l=0.9u w=10u
R84 VDD N133 0.001
M167 N133 N182 N183 N133 pmos l=0.9u w=10u
M168 N183 N182 0 0 nmos l=0.9u w=10u
R85 VDD N134 0.001
M169 N134 N183 N184 N134 pmos l=0.9u w=10u
M170 N184 N183 0 0 nmos l=0.9u w=10u
R86 VDD N135 0.001
M171 N135 N184 N185 N135 pmos l=0.9u w=10u
M172 N185 N184 0 0 nmos l=0.9u w=10u
R87 VDD N136 0.001
M173 N136 N185 N186 N136 pmos l=0.9u w=10u
M174 N186 N185 0 0 nmos l=0.9u w=10u
R88 VDD N137 0.001
M175 N137 N186 N187 N137 pmos l=0.9u w=10u
M176 N187 N186 0 0 nmos l=0.9u w=10u
R89 VDD N138 0.001
M177 N138 N187 N188 N138 pmos l=0.9u w=10u
M178 N188 N187 0 0 nmos l=0.9u w=10u
R90 VDD N139 0.001
M179 N139 N188 N189 N139 pmos l=0.9u w=10u
M180 N189 N188 0 0 nmos l=0.9u w=10u
R91 VDD N140 0.001
M181 N140 N189 N190 N140 pmos l=0.9u w=10u
M182 N190 N189 0 0 nmos l=0.9u w=10u
R92 VDD N141 0.001
M183 N141 N190 N191 N141 pmos l=0.9u w=10u
M184 N191 N190 0 0 nmos l=0.9u w=10u
R93 VDD N142 0.001
M185 N142 N191 N192 N142 pmos l=0.9u w=10u
M186 N192 N191 0 0 nmos l=0.9u w=10u
R94 VDD N143 0.001
M187 N143 N192 N193 N143 pmos l=0.9u w=10u
M188 N193 N192 0 0 nmos l=0.9u w=10u
R95 VDD N144 0.001
M189 N144 N193 N194 N144 pmos l=0.9u w=10u
M190 N194 N193 0 0 nmos l=0.9u w=10u
R96 VDD N145 0.001
M191 N145 N194 N195 N145 pmos l=0.9u w=10u
M192 N195 N194 0 0 nmos l=0.9u w=10u
R97 VDD N146 0.001
M193 N146 N195 N196 N146 pmos l=0.9u w=10u
M194 N196 N195 0 0 nmos l=0.9u w=10u
R98 VDD N147 0.001
M195 N147 N196 N197 N147 pmos l=0.9u w=10u
M196 N197 N196 0 0 nmos l=0.9u w=10u
R99 VDD N148 0.001
M197 N148 N197 N198 N148 pmos l=0.9u w=10u
M198 N198 N197 0 0 nmos l=0.9u w=10u
R100 VDD N149 0.001
M199 N149 N198 vout2 N149 pmos l=0.9u w=10u
M200 vout2 N198 0 0 nmos l=0.9u w=10u
R101 VDD N199 0.001
M201 N199 vout2 N249 N199 pmos l=0.9u w=10u
M202 N249 vout2 0 0 nmos l=0.9u w=10u
R102 VDD N200 0.001
M203 N200 N249 N250 N200 pmos l=0.9u w=10u
M204 N250 N249 0 0 nmos l=0.9u w=10u
R103 VDD N201 0.001
M205 N201 N250 N251 N201 pmos l=0.9u w=10u
M206 N251 N250 0 0 nmos l=0.9u w=10u
R104 VDD N202 0.001
M207 N202 N251 N252 N202 pmos l=0.9u w=10u
M208 N252 N251 0 0 nmos l=0.9u w=10u
R105 VDD N203 0.001
M209 N203 N252 N253 N203 pmos l=0.9u w=10u
M210 N253 N252 0 0 nmos l=0.9u w=10u
R106 VDD N204 0.001
M211 N204 N253 N254 N204 pmos l=0.9u w=10u
M212 N254 N253 0 0 nmos l=0.9u w=10u
R107 VDD N205 0.001
M213 N205 N254 N255 N205 pmos l=0.9u w=10u
M214 N255 N254 0 0 nmos l=0.9u w=10u
R108 VDD N206 0.001
M215 N206 N255 N256 N206 pmos l=0.9u w=10u
M216 N256 N255 0 0 nmos l=0.9u w=10u
R109 VDD N207 0.001
M217 N207 N256 N257 N207 pmos l=0.9u w=10u
M218 N257 N256 0 0 nmos l=0.9u w=10u
R110 VDD N208 0.001
M219 N208 N257 N258 N208 pmos l=0.9u w=10u
M220 N258 N257 0 0 nmos l=0.9u w=10u
R111 VDD N209 0.001
M221 N209 N258 N259 N209 pmos l=0.9u w=10u
M222 N259 N258 0 0 nmos l=0.9u w=10u
R112 VDD N210 0.001
M223 N210 N259 N260 N210 pmos l=0.9u w=10u
M224 N260 N259 0 0 nmos l=0.9u w=10u
R113 VDD N211 0.001
M225 N211 N260 N261 N211 pmos l=0.9u w=10u
M226 N261 N260 0 0 nmos l=0.9u w=10u
R114 VDD N212 0.001
M227 N212 N261 N262 N212 pmos l=0.9u w=10u
M228 N262 N261 0 0 nmos l=0.9u w=10u
R115 VDD N213 0.001
M229 N213 N262 N263 N213 pmos l=0.9u w=10u
M230 N263 N262 0 0 nmos l=0.9u w=10u
R116 VDD N214 0.001
M231 N214 N263 N264 N214 pmos l=0.9u w=10u
M232 N264 N263 0 0 nmos l=0.9u w=10u
R117 VDD N215 0.001
M233 N215 N264 N265 N215 pmos l=0.9u w=10u
M234 N265 N264 0 0 nmos l=0.9u w=10u
R118 VDD N216 0.001
M235 N216 N265 N266 N216 pmos l=0.9u w=10u
M236 N266 N265 0 0 nmos l=0.9u w=10u
R119 VDD N217 0.001
M237 N217 N266 N267 N217 pmos l=0.9u w=10u
M238 N267 N266 0 0 nmos l=0.9u w=10u
R120 VDD N218 0.001
M239 N218 N267 N268 N218 pmos l=0.9u w=10u
M240 N268 N267 0 0 nmos l=0.9u w=10u
R121 VDD N219 0.001
M241 N219 N268 N269 N219 pmos l=0.9u w=10u
M242 N269 N268 0 0 nmos l=0.9u w=10u
R122 VDD N220 0.001
M243 N220 N269 N270 N220 pmos l=0.9u w=10u
M244 N270 N269 0 0 nmos l=0.9u w=10u
R123 VDD N221 0.001
M245 N221 N270 N271 N221 pmos l=0.9u w=10u
M246 N271 N270 0 0 nmos l=0.9u w=10u
R124 VDD N222 0.001
M247 N222 N271 N272 N222 pmos l=0.9u w=10u
M248 N272 N271 0 0 nmos l=0.9u w=10u
R125 VDD N223 0.001
M249 N223 N272 N273 N223 pmos l=0.9u w=10u
M250 N273 N272 0 0 nmos l=0.9u w=10u
R126 VDD N224 0.001
M251 N224 N273 N274 N224 pmos l=0.9u w=10u
M252 N274 N273 0 0 nmos l=0.9u w=10u
R127 VDD N225 0.001
M253 N225 N274 N275 N225 pmos l=0.9u w=10u
M254 N275 N274 0 0 nmos l=0.9u w=10u
R128 VDD N226 0.001
M255 N226 N275 N276 N226 pmos l=0.9u w=10u
M256 N276 N275 0 0 nmos l=0.9u w=10u
R129 VDD N227 0.001
M257 N227 N276 N277 N227 pmos l=0.9u w=10u
M258 N277 N276 0 0 nmos l=0.9u w=10u
R130 VDD N228 0.001
M259 N228 N277 N278 N228 pmos l=0.9u w=10u
M260 N278 N277 0 0 nmos l=0.9u w=10u
R131 VDD N229 0.001
M261 N229 N278 N279 N229 pmos l=0.9u w=10u
M262 N279 N278 0 0 nmos l=0.9u w=10u
R132 VDD N230 0.001
M263 N230 N279 N280 N230 pmos l=0.9u w=10u
M264 N280 N279 0 0 nmos l=0.9u w=10u
R133 VDD N231 0.001
M265 N231 N280 N281 N231 pmos l=0.9u w=10u
M266 N281 N280 0 0 nmos l=0.9u w=10u
R134 VDD N232 0.001
M267 N232 N281 N282 N232 pmos l=0.9u w=10u
M268 N282 N281 0 0 nmos l=0.9u w=10u
R135 VDD N233 0.001
M269 N233 N282 N283 N233 pmos l=0.9u w=10u
M270 N283 N282 0 0 nmos l=0.9u w=10u
R136 VDD N234 0.001
M271 N234 N283 N284 N234 pmos l=0.9u w=10u
M272 N284 N283 0 0 nmos l=0.9u w=10u
R137 VDD N235 0.001
M273 N235 N284 N285 N235 pmos l=0.9u w=10u
M274 N285 N284 0 0 nmos l=0.9u w=10u
R138 VDD N236 0.001
M275 N236 N285 N286 N236 pmos l=0.9u w=10u
M276 N286 N285 0 0 nmos l=0.9u w=10u
R139 VDD N237 0.001
M277 N237 N286 N287 N237 pmos l=0.9u w=10u
M278 N287 N286 0 0 nmos l=0.9u w=10u
R140 VDD N238 0.001
M279 N238 N287 N288 N238 pmos l=0.9u w=10u
M280 N288 N287 0 0 nmos l=0.9u w=10u
R141 VDD N239 0.001
M281 N239 N288 N289 N239 pmos l=0.9u w=10u
M282 N289 N288 0 0 nmos l=0.9u w=10u
R142 VDD N240 0.001
M283 N240 N289 N290 N240 pmos l=0.9u w=10u
M284 N290 N289 0 0 nmos l=0.9u w=10u
R143 VDD N241 0.001
M285 N241 N290 N291 N241 pmos l=0.9u w=10u
M286 N291 N290 0 0 nmos l=0.9u w=10u
R144 VDD N242 0.001
M287 N242 N291 N292 N242 pmos l=0.9u w=10u
M288 N292 N291 0 0 nmos l=0.9u w=10u
R145 VDD N243 0.001
M289 N243 N292 N293 N243 pmos l=0.9u w=10u
M290 N293 N292 0 0 nmos l=0.9u w=10u
R146 VDD N244 0.001
M291 N244 N293 N294 N244 pmos l=0.9u w=10u
M292 N294 N293 0 0 nmos l=0.9u w=10u
R147 VDD N245 0.001
M293 N245 N294 N295 N245 pmos l=0.9u w=10u
M294 N295 N294 0 0 nmos l=0.9u w=10u
R148 VDD N246 0.001
M295 N246 N295 N296 N246 pmos l=0.9u w=10u
M296 N296 N295 0 0 nmos l=0.9u w=10u
R149 VDD N247 0.001
M297 N247 N296 N297 N247 pmos l=0.9u w=10u
M298 N297 N296 0 0 nmos l=0.9u w=10u
R150 VDD N248 0.001
M299 N248 N297 vout3 N248 pmos l=0.9u w=10u
M300 vout3 N297 0 0 nmos l=0.9u w=10u
R151 VDD N298 0.001
M301 N298 vout3 N348 N298 pmos l=0.9u w=10u
M302 N348 vout3 0 0 nmos l=0.9u w=10u
R152 VDD N299 0.001
M303 N299 N348 N349 N299 pmos l=0.9u w=10u
M304 N349 N348 0 0 nmos l=0.9u w=10u
R153 VDD N300 0.001
M305 N300 N349 N350 N300 pmos l=0.9u w=10u
M306 N350 N349 0 0 nmos l=0.9u w=10u
R154 VDD N301 0.001
M307 N301 N350 N351 N301 pmos l=0.9u w=10u
M308 N351 N350 0 0 nmos l=0.9u w=10u
R155 VDD N302 0.001
M309 N302 N351 N352 N302 pmos l=0.9u w=10u
M310 N352 N351 0 0 nmos l=0.9u w=10u
R156 VDD N303 0.001
M311 N303 N352 N353 N303 pmos l=0.9u w=10u
M312 N353 N352 0 0 nmos l=0.9u w=10u
R157 VDD N304 0.001
M313 N304 N353 N354 N304 pmos l=0.9u w=10u
M314 N354 N353 0 0 nmos l=0.9u w=10u
R158 VDD N305 0.001
M315 N305 N354 N355 N305 pmos l=0.9u w=10u
M316 N355 N354 0 0 nmos l=0.9u w=10u
R159 VDD N306 0.001
M317 N306 N355 N356 N306 pmos l=0.9u w=10u
M318 N356 N355 0 0 nmos l=0.9u w=10u
R160 VDD N307 0.001
M319 N307 N356 N357 N307 pmos l=0.9u w=10u
M320 N357 N356 0 0 nmos l=0.9u w=10u
R161 VDD N308 0.001
M321 N308 N357 N358 N308 pmos l=0.9u w=10u
M322 N358 N357 0 0 nmos l=0.9u w=10u
R162 VDD N309 0.001
M323 N309 N358 N359 N309 pmos l=0.9u w=10u
M324 N359 N358 0 0 nmos l=0.9u w=10u
R163 VDD N310 0.001
M325 N310 N359 N360 N310 pmos l=0.9u w=10u
M326 N360 N359 0 0 nmos l=0.9u w=10u
R164 VDD N311 0.001
M327 N311 N360 N361 N311 pmos l=0.9u w=10u
M328 N361 N360 0 0 nmos l=0.9u w=10u
R165 VDD N312 0.001
M329 N312 N361 N362 N312 pmos l=0.9u w=10u
M330 N362 N361 0 0 nmos l=0.9u w=10u
R166 VDD N313 0.001
M331 N313 N362 N363 N313 pmos l=0.9u w=10u
M332 N363 N362 0 0 nmos l=0.9u w=10u
R167 VDD N314 0.001
M333 N314 N363 N364 N314 pmos l=0.9u w=10u
M334 N364 N363 0 0 nmos l=0.9u w=10u
R168 VDD N315 0.001
M335 N315 N364 N365 N315 pmos l=0.9u w=10u
M336 N365 N364 0 0 nmos l=0.9u w=10u
R169 VDD N316 0.001
M337 N316 N365 N366 N316 pmos l=0.9u w=10u
M338 N366 N365 0 0 nmos l=0.9u w=10u
R170 VDD N317 0.001
M339 N317 N366 N367 N317 pmos l=0.9u w=10u
M340 N367 N366 0 0 nmos l=0.9u w=10u
R171 VDD N318 0.001
M341 N318 N367 N368 N318 pmos l=0.9u w=10u
M342 N368 N367 0 0 nmos l=0.9u w=10u
R172 VDD N319 0.001
M343 N319 N368 N369 N319 pmos l=0.9u w=10u
M344 N369 N368 0 0 nmos l=0.9u w=10u
R173 VDD N320 0.001
M345 N320 N369 N370 N320 pmos l=0.9u w=10u
M346 N370 N369 0 0 nmos l=0.9u w=10u
R174 VDD N321 0.001
M347 N321 N370 N371 N321 pmos l=0.9u w=10u
M348 N371 N370 0 0 nmos l=0.9u w=10u
R175 VDD N322 0.001
M349 N322 N371 N372 N322 pmos l=0.9u w=10u
M350 N372 N371 0 0 nmos l=0.9u w=10u
R176 VDD N323 0.001
M351 N323 N372 N373 N323 pmos l=0.9u w=10u
M352 N373 N372 0 0 nmos l=0.9u w=10u
R177 VDD N324 0.001
M353 N324 N373 N374 N324 pmos l=0.9u w=10u
M354 N374 N373 0 0 nmos l=0.9u w=10u
R178 VDD N325 0.001
M355 N325 N374 N375 N325 pmos l=0.9u w=10u
M356 N375 N374 0 0 nmos l=0.9u w=10u
R179 VDD N326 0.001
M357 N326 N375 N376 N326 pmos l=0.9u w=10u
M358 N376 N375 0 0 nmos l=0.9u w=10u
R180 VDD N327 0.001
M359 N327 N376 N377 N327 pmos l=0.9u w=10u
M360 N377 N376 0 0 nmos l=0.9u w=10u
R181 VDD N328 0.001
M361 N328 N377 N378 N328 pmos l=0.9u w=10u
M362 N378 N377 0 0 nmos l=0.9u w=10u
R182 VDD N329 0.001
M363 N329 N378 N379 N329 pmos l=0.9u w=10u
M364 N379 N378 0 0 nmos l=0.9u w=10u
R183 VDD N330 0.001
M365 N330 N379 N380 N330 pmos l=0.9u w=10u
M366 N380 N379 0 0 nmos l=0.9u w=10u
R184 VDD N331 0.001
M367 N331 N380 N381 N331 pmos l=0.9u w=10u
M368 N381 N380 0 0 nmos l=0.9u w=10u
R185 VDD N332 0.001
M369 N332 N381 N382 N332 pmos l=0.9u w=10u
M370 N382 N381 0 0 nmos l=0.9u w=10u
R186 VDD N333 0.001
M371 N333 N382 N383 N333 pmos l=0.9u w=10u
M372 N383 N382 0 0 nmos l=0.9u w=10u
R187 VDD N334 0.001
M373 N334 N383 N384 N334 pmos l=0.9u w=10u
M374 N384 N383 0 0 nmos l=0.9u w=10u
R188 VDD N335 0.001
M375 N335 N384 N385 N335 pmos l=0.9u w=10u
M376 N385 N384 0 0 nmos l=0.9u w=10u
R189 VDD N336 0.001
M377 N336 N385 N386 N336 pmos l=0.9u w=10u
M378 N386 N385 0 0 nmos l=0.9u w=10u
R190 VDD N337 0.001
M379 N337 N386 N387 N337 pmos l=0.9u w=10u
M380 N387 N386 0 0 nmos l=0.9u w=10u
R191 VDD N338 0.001
M381 N338 N387 N388 N338 pmos l=0.9u w=10u
M382 N388 N387 0 0 nmos l=0.9u w=10u
R192 VDD N339 0.001
M383 N339 N388 N389 N339 pmos l=0.9u w=10u
M384 N389 N388 0 0 nmos l=0.9u w=10u
R193 VDD N340 0.001
M385 N340 N389 N390 N340 pmos l=0.9u w=10u
M386 N390 N389 0 0 nmos l=0.9u w=10u
R194 VDD N341 0.001
M387 N341 N390 N391 N341 pmos l=0.9u w=10u
M388 N391 N390 0 0 nmos l=0.9u w=10u
R195 VDD N342 0.001
M389 N342 N391 N392 N342 pmos l=0.9u w=10u
M390 N392 N391 0 0 nmos l=0.9u w=10u
R196 VDD N343 0.001
M391 N343 N392 N393 N343 pmos l=0.9u w=10u
M392 N393 N392 0 0 nmos l=0.9u w=10u
R197 VDD N344 0.001
M393 N344 N393 N394 N344 pmos l=0.9u w=10u
M394 N394 N393 0 0 nmos l=0.9u w=10u
R198 VDD N345 0.001
M395 N345 N394 N395 N345 pmos l=0.9u w=10u
M396 N395 N394 0 0 nmos l=0.9u w=10u
R199 VDD N346 0.001
M397 N346 N395 N396 N346 pmos l=0.9u w=10u
M398 N396 N395 0 0 nmos l=0.9u w=10u
R200 VDD N347 0.001
M399 N347 N396 vout4 N347 pmos l=0.9u w=10u
M400 vout4 N396 0 0 nmos l=0.9u w=10u
R201 VDD N397 0.001
M401 N397 vout4 N447 N397 pmos l=0.9u w=10u
M402 N447 vout4 0 0 nmos l=0.9u w=10u
R202 VDD N398 0.001
M403 N398 N447 N448 N398 pmos l=0.9u w=10u
M404 N448 N447 0 0 nmos l=0.9u w=10u
R203 VDD N399 0.001
M405 N399 N448 N449 N399 pmos l=0.9u w=10u
M406 N449 N448 0 0 nmos l=0.9u w=10u
R204 VDD N400 0.001
M407 N400 N449 N450 N400 pmos l=0.9u w=10u
M408 N450 N449 0 0 nmos l=0.9u w=10u
R205 VDD N401 0.001
M409 N401 N450 N451 N401 pmos l=0.9u w=10u
M410 N451 N450 0 0 nmos l=0.9u w=10u
R206 VDD N402 0.001
M411 N402 N451 N452 N402 pmos l=0.9u w=10u
M412 N452 N451 0 0 nmos l=0.9u w=10u
R207 VDD N403 0.001
M413 N403 N452 N453 N403 pmos l=0.9u w=10u
M414 N453 N452 0 0 nmos l=0.9u w=10u
R208 VDD N404 0.001
M415 N404 N453 N454 N404 pmos l=0.9u w=10u
M416 N454 N453 0 0 nmos l=0.9u w=10u
R209 VDD N405 0.001
M417 N405 N454 N455 N405 pmos l=0.9u w=10u
M418 N455 N454 0 0 nmos l=0.9u w=10u
R210 VDD N406 0.001
M419 N406 N455 N456 N406 pmos l=0.9u w=10u
M420 N456 N455 0 0 nmos l=0.9u w=10u
R211 VDD N407 0.001
M421 N407 N456 N457 N407 pmos l=0.9u w=10u
M422 N457 N456 0 0 nmos l=0.9u w=10u
R212 VDD N408 0.001
M423 N408 N457 N458 N408 pmos l=0.9u w=10u
M424 N458 N457 0 0 nmos l=0.9u w=10u
R213 VDD N409 0.001
M425 N409 N458 N459 N409 pmos l=0.9u w=10u
M426 N459 N458 0 0 nmos l=0.9u w=10u
R214 VDD N410 0.001
M427 N410 N459 N460 N410 pmos l=0.9u w=10u
M428 N460 N459 0 0 nmos l=0.9u w=10u
R215 VDD N411 0.001
M429 N411 N460 N461 N411 pmos l=0.9u w=10u
M430 N461 N460 0 0 nmos l=0.9u w=10u
R216 VDD N412 0.001
M431 N412 N461 N462 N412 pmos l=0.9u w=10u
M432 N462 N461 0 0 nmos l=0.9u w=10u
R217 VDD N413 0.001
M433 N413 N462 N463 N413 pmos l=0.9u w=10u
M434 N463 N462 0 0 nmos l=0.9u w=10u
R218 VDD N414 0.001
M435 N414 N463 N464 N414 pmos l=0.9u w=10u
M436 N464 N463 0 0 nmos l=0.9u w=10u
R219 VDD N415 0.001
M437 N415 N464 N465 N415 pmos l=0.9u w=10u
M438 N465 N464 0 0 nmos l=0.9u w=10u
R220 VDD N416 0.001
M439 N416 N465 N466 N416 pmos l=0.9u w=10u
M440 N466 N465 0 0 nmos l=0.9u w=10u
R221 VDD N417 0.001
M441 N417 N466 N467 N417 pmos l=0.9u w=10u
M442 N467 N466 0 0 nmos l=0.9u w=10u
R222 VDD N418 0.001
M443 N418 N467 N468 N418 pmos l=0.9u w=10u
M444 N468 N467 0 0 nmos l=0.9u w=10u
R223 VDD N419 0.001
M445 N419 N468 N469 N419 pmos l=0.9u w=10u
M446 N469 N468 0 0 nmos l=0.9u w=10u
R224 VDD N420 0.001
M447 N420 N469 N470 N420 pmos l=0.9u w=10u
M448 N470 N469 0 0 nmos l=0.9u w=10u
R225 VDD N421 0.001
M449 N421 N470 N471 N421 pmos l=0.9u w=10u
M450 N471 N470 0 0 nmos l=0.9u w=10u
R226 VDD N422 0.001
M451 N422 N471 N472 N422 pmos l=0.9u w=10u
M452 N472 N471 0 0 nmos l=0.9u w=10u
R227 VDD N423 0.001
M453 N423 N472 N473 N423 pmos l=0.9u w=10u
M454 N473 N472 0 0 nmos l=0.9u w=10u
R228 VDD N424 0.001
M455 N424 N473 N474 N424 pmos l=0.9u w=10u
M456 N474 N473 0 0 nmos l=0.9u w=10u
R229 VDD N425 0.001
M457 N425 N474 N475 N425 pmos l=0.9u w=10u
M458 N475 N474 0 0 nmos l=0.9u w=10u
R230 VDD N426 0.001
M459 N426 N475 N476 N426 pmos l=0.9u w=10u
M460 N476 N475 0 0 nmos l=0.9u w=10u
R231 VDD N427 0.001
M461 N427 N476 N477 N427 pmos l=0.9u w=10u
M462 N477 N476 0 0 nmos l=0.9u w=10u
R232 VDD N428 0.001
M463 N428 N477 N478 N428 pmos l=0.9u w=10u
M464 N478 N477 0 0 nmos l=0.9u w=10u
R233 VDD N429 0.001
M465 N429 N478 N479 N429 pmos l=0.9u w=10u
M466 N479 N478 0 0 nmos l=0.9u w=10u
R234 VDD N430 0.001
M467 N430 N479 N480 N430 pmos l=0.9u w=10u
M468 N480 N479 0 0 nmos l=0.9u w=10u
R235 VDD N431 0.001
M469 N431 N480 N481 N431 pmos l=0.9u w=10u
M470 N481 N480 0 0 nmos l=0.9u w=10u
R236 VDD N432 0.001
M471 N432 N481 N482 N432 pmos l=0.9u w=10u
M472 N482 N481 0 0 nmos l=0.9u w=10u
R237 VDD N433 0.001
M473 N433 N482 N483 N433 pmos l=0.9u w=10u
M474 N483 N482 0 0 nmos l=0.9u w=10u
R238 VDD N434 0.001
M475 N434 N483 N484 N434 pmos l=0.9u w=10u
M476 N484 N483 0 0 nmos l=0.9u w=10u
R239 VDD N435 0.001
M477 N435 N484 N485 N435 pmos l=0.9u w=10u
M478 N485 N484 0 0 nmos l=0.9u w=10u
R240 VDD N436 0.001
M479 N436 N485 N486 N436 pmos l=0.9u w=10u
M480 N486 N485 0 0 nmos l=0.9u w=10u
R241 VDD N437 0.001
M481 N437 N486 N487 N437 pmos l=0.9u w=10u
M482 N487 N486 0 0 nmos l=0.9u w=10u
R242 VDD N438 0.001
M483 N438 N487 N488 N438 pmos l=0.9u w=10u
M484 N488 N487 0 0 nmos l=0.9u w=10u
R243 VDD N439 0.001
M485 N439 N488 N489 N439 pmos l=0.9u w=10u
M486 N489 N488 0 0 nmos l=0.9u w=10u
R244 VDD N440 0.001
M487 N440 N489 N490 N440 pmos l=0.9u w=10u
M488 N490 N489 0 0 nmos l=0.9u w=10u
R245 VDD N441 0.001
M489 N441 N490 N491 N441 pmos l=0.9u w=10u
M490 N491 N490 0 0 nmos l=0.9u w=10u
R246 VDD N442 0.001
M491 N442 N491 N492 N442 pmos l=0.9u w=10u
M492 N492 N491 0 0 nmos l=0.9u w=10u
R247 VDD N443 0.001
M493 N443 N492 N493 N443 pmos l=0.9u w=10u
M494 N493 N492 0 0 nmos l=0.9u w=10u
R248 VDD N444 0.001
M495 N444 N493 N494 N444 pmos l=0.9u w=10u
M496 N494 N493 0 0 nmos l=0.9u w=10u
R249 VDD N445 0.001
M497 N445 N494 N495 N445 pmos l=0.9u w=10u
M498 N495 N494 0 0 nmos l=0.9u w=10u
R250 VDD N446 0.001
M499 N446 N495 vout5 N446 pmos l=0.9u w=10u
M500 vout5 N495 0 0 nmos l=0.9u w=10u
R251 VDD N496 0.001
M501 N496 vout5 N546 N496 pmos l=0.9u w=10u
M502 N546 vout5 0 0 nmos l=0.9u w=10u
R252 VDD N497 0.001
M503 N497 N546 N547 N497 pmos l=0.9u w=10u
M504 N547 N546 0 0 nmos l=0.9u w=10u
R253 VDD N498 0.001
M505 N498 N547 N548 N498 pmos l=0.9u w=10u
M506 N548 N547 0 0 nmos l=0.9u w=10u
R254 VDD N499 0.001
M507 N499 N548 N549 N499 pmos l=0.9u w=10u
M508 N549 N548 0 0 nmos l=0.9u w=10u
R255 VDD N500 0.001
M509 N500 N549 N550 N500 pmos l=0.9u w=10u
M510 N550 N549 0 0 nmos l=0.9u w=10u
R256 VDD N501 0.001
M511 N501 N550 N551 N501 pmos l=0.9u w=10u
M512 N551 N550 0 0 nmos l=0.9u w=10u
R257 VDD N502 0.001
M513 N502 N551 N552 N502 pmos l=0.9u w=10u
M514 N552 N551 0 0 nmos l=0.9u w=10u
R258 VDD N503 0.001
M515 N503 N552 N553 N503 pmos l=0.9u w=10u
M516 N553 N552 0 0 nmos l=0.9u w=10u
R259 VDD N504 0.001
M517 N504 N553 N554 N504 pmos l=0.9u w=10u
M518 N554 N553 0 0 nmos l=0.9u w=10u
R260 VDD N505 0.001
M519 N505 N554 N555 N505 pmos l=0.9u w=10u
M520 N555 N554 0 0 nmos l=0.9u w=10u
R261 VDD N506 0.001
M521 N506 N555 N556 N506 pmos l=0.9u w=10u
M522 N556 N555 0 0 nmos l=0.9u w=10u
R262 VDD N507 0.001
M523 N507 N556 N557 N507 pmos l=0.9u w=10u
M524 N557 N556 0 0 nmos l=0.9u w=10u
R263 VDD N508 0.001
M525 N508 N557 N558 N508 pmos l=0.9u w=10u
M526 N558 N557 0 0 nmos l=0.9u w=10u
R264 VDD N509 0.001
M527 N509 N558 N559 N509 pmos l=0.9u w=10u
M528 N559 N558 0 0 nmos l=0.9u w=10u
R265 VDD N510 0.001
M529 N510 N559 N560 N510 pmos l=0.9u w=10u
M530 N560 N559 0 0 nmos l=0.9u w=10u
R266 VDD N511 0.001
M531 N511 N560 N561 N511 pmos l=0.9u w=10u
M532 N561 N560 0 0 nmos l=0.9u w=10u
R267 VDD N512 0.001
M533 N512 N561 N562 N512 pmos l=0.9u w=10u
M534 N562 N561 0 0 nmos l=0.9u w=10u
R268 VDD N513 0.001
M535 N513 N562 N563 N513 pmos l=0.9u w=10u
M536 N563 N562 0 0 nmos l=0.9u w=10u
R269 VDD N514 0.001
M537 N514 N563 N564 N514 pmos l=0.9u w=10u
M538 N564 N563 0 0 nmos l=0.9u w=10u
R270 VDD N515 0.001
M539 N515 N564 N565 N515 pmos l=0.9u w=10u
M540 N565 N564 0 0 nmos l=0.9u w=10u
R271 VDD N516 0.001
M541 N516 N565 N566 N516 pmos l=0.9u w=10u
M542 N566 N565 0 0 nmos l=0.9u w=10u
R272 VDD N517 0.001
M543 N517 N566 N567 N517 pmos l=0.9u w=10u
M544 N567 N566 0 0 nmos l=0.9u w=10u
R273 VDD N518 0.001
M545 N518 N567 N568 N518 pmos l=0.9u w=10u
M546 N568 N567 0 0 nmos l=0.9u w=10u
R274 VDD N519 0.001
M547 N519 N568 N569 N519 pmos l=0.9u w=10u
M548 N569 N568 0 0 nmos l=0.9u w=10u
R275 VDD N520 0.001
M549 N520 N569 N570 N520 pmos l=0.9u w=10u
M550 N570 N569 0 0 nmos l=0.9u w=10u
R276 VDD N521 0.001
M551 N521 N570 N571 N521 pmos l=0.9u w=10u
M552 N571 N570 0 0 nmos l=0.9u w=10u
R277 VDD N522 0.001
M553 N522 N571 N572 N522 pmos l=0.9u w=10u
M554 N572 N571 0 0 nmos l=0.9u w=10u
R278 VDD N523 0.001
M555 N523 N572 N573 N523 pmos l=0.9u w=10u
M556 N573 N572 0 0 nmos l=0.9u w=10u
R279 VDD N524 0.001
M557 N524 N573 N574 N524 pmos l=0.9u w=10u
M558 N574 N573 0 0 nmos l=0.9u w=10u
R280 VDD N525 0.001
M559 N525 N574 N575 N525 pmos l=0.9u w=10u
M560 N575 N574 0 0 nmos l=0.9u w=10u
R281 VDD N526 0.001
M561 N526 N575 N576 N526 pmos l=0.9u w=10u
M562 N576 N575 0 0 nmos l=0.9u w=10u
R282 VDD N527 0.001
M563 N527 N576 N577 N527 pmos l=0.9u w=10u
M564 N577 N576 0 0 nmos l=0.9u w=10u
R283 VDD N528 0.001
M565 N528 N577 N578 N528 pmos l=0.9u w=10u
M566 N578 N577 0 0 nmos l=0.9u w=10u
R284 VDD N529 0.001
M567 N529 N578 N579 N529 pmos l=0.9u w=10u
M568 N579 N578 0 0 nmos l=0.9u w=10u
R285 VDD N530 0.001
M569 N530 N579 N580 N530 pmos l=0.9u w=10u
M570 N580 N579 0 0 nmos l=0.9u w=10u
R286 VDD N531 0.001
M571 N531 N580 N581 N531 pmos l=0.9u w=10u
M572 N581 N580 0 0 nmos l=0.9u w=10u
R287 VDD N532 0.001
M573 N532 N581 N582 N532 pmos l=0.9u w=10u
M574 N582 N581 0 0 nmos l=0.9u w=10u
R288 VDD N533 0.001
M575 N533 N582 N583 N533 pmos l=0.9u w=10u
M576 N583 N582 0 0 nmos l=0.9u w=10u
R289 VDD N534 0.001
M577 N534 N583 N584 N534 pmos l=0.9u w=10u
M578 N584 N583 0 0 nmos l=0.9u w=10u
R290 VDD N535 0.001
M579 N535 N584 N585 N535 pmos l=0.9u w=10u
M580 N585 N584 0 0 nmos l=0.9u w=10u
R291 VDD N536 0.001
M581 N536 N585 N586 N536 pmos l=0.9u w=10u
M582 N586 N585 0 0 nmos l=0.9u w=10u
R292 VDD N537 0.001
M583 N537 N586 N587 N537 pmos l=0.9u w=10u
M584 N587 N586 0 0 nmos l=0.9u w=10u
R293 VDD N538 0.001
M585 N538 N587 N588 N538 pmos l=0.9u w=10u
M586 N588 N587 0 0 nmos l=0.9u w=10u
R294 VDD N539 0.001
M587 N539 N588 N589 N539 pmos l=0.9u w=10u
M588 N589 N588 0 0 nmos l=0.9u w=10u
R295 VDD N540 0.001
M589 N540 N589 N590 N540 pmos l=0.9u w=10u
M590 N590 N589 0 0 nmos l=0.9u w=10u
R296 VDD N541 0.001
M591 N541 N590 N591 N541 pmos l=0.9u w=10u
M592 N591 N590 0 0 nmos l=0.9u w=10u
R297 VDD N542 0.001
M593 N542 N591 N592 N542 pmos l=0.9u w=10u
M594 N592 N591 0 0 nmos l=0.9u w=10u
R298 VDD N543 0.001
M595 N543 N592 N593 N543 pmos l=0.9u w=10u
M596 N593 N592 0 0 nmos l=0.9u w=10u
R299 VDD N544 0.001
M597 N544 N593 N594 N544 pmos l=0.9u w=10u
M598 N594 N593 0 0 nmos l=0.9u w=10u
R300 VDD N545 0.001
M599 N545 N594 vout6 N545 pmos l=0.9u w=10u
M600 vout6 N594 0 0 nmos l=0.9u w=10u
R301 VDD N595 0.001
M601 N595 vout6 N645 N595 pmos l=0.9u w=10u
M602 N645 vout6 0 0 nmos l=0.9u w=10u
R302 VDD N596 0.001
M603 N596 N645 N646 N596 pmos l=0.9u w=10u
M604 N646 N645 0 0 nmos l=0.9u w=10u
R303 VDD N597 0.001
M605 N597 N646 N647 N597 pmos l=0.9u w=10u
M606 N647 N646 0 0 nmos l=0.9u w=10u
R304 VDD N598 0.001
M607 N598 N647 N648 N598 pmos l=0.9u w=10u
M608 N648 N647 0 0 nmos l=0.9u w=10u
R305 VDD N599 0.001
M609 N599 N648 N649 N599 pmos l=0.9u w=10u
M610 N649 N648 0 0 nmos l=0.9u w=10u
R306 VDD N600 0.001
M611 N600 N649 N650 N600 pmos l=0.9u w=10u
M612 N650 N649 0 0 nmos l=0.9u w=10u
R307 VDD N601 0.001
M613 N601 N650 N651 N601 pmos l=0.9u w=10u
M614 N651 N650 0 0 nmos l=0.9u w=10u
R308 VDD N602 0.001
M615 N602 N651 N652 N602 pmos l=0.9u w=10u
M616 N652 N651 0 0 nmos l=0.9u w=10u
R309 VDD N603 0.001
M617 N603 N652 N653 N603 pmos l=0.9u w=10u
M618 N653 N652 0 0 nmos l=0.9u w=10u
R310 VDD N604 0.001
M619 N604 N653 N654 N604 pmos l=0.9u w=10u
M620 N654 N653 0 0 nmos l=0.9u w=10u
R311 VDD N605 0.001
M621 N605 N654 N655 N605 pmos l=0.9u w=10u
M622 N655 N654 0 0 nmos l=0.9u w=10u
R312 VDD N606 0.001
M623 N606 N655 N656 N606 pmos l=0.9u w=10u
M624 N656 N655 0 0 nmos l=0.9u w=10u
R313 VDD N607 0.001
M625 N607 N656 N657 N607 pmos l=0.9u w=10u
M626 N657 N656 0 0 nmos l=0.9u w=10u
R314 VDD N608 0.001
M627 N608 N657 N658 N608 pmos l=0.9u w=10u
M628 N658 N657 0 0 nmos l=0.9u w=10u
R315 VDD N609 0.001
M629 N609 N658 N659 N609 pmos l=0.9u w=10u
M630 N659 N658 0 0 nmos l=0.9u w=10u
R316 VDD N610 0.001
M631 N610 N659 N660 N610 pmos l=0.9u w=10u
M632 N660 N659 0 0 nmos l=0.9u w=10u
R317 VDD N611 0.001
M633 N611 N660 N661 N611 pmos l=0.9u w=10u
M634 N661 N660 0 0 nmos l=0.9u w=10u
R318 VDD N612 0.001
M635 N612 N661 N662 N612 pmos l=0.9u w=10u
M636 N662 N661 0 0 nmos l=0.9u w=10u
R319 VDD N613 0.001
M637 N613 N662 N663 N613 pmos l=0.9u w=10u
M638 N663 N662 0 0 nmos l=0.9u w=10u
R320 VDD N614 0.001
M639 N614 N663 N664 N614 pmos l=0.9u w=10u
M640 N664 N663 0 0 nmos l=0.9u w=10u
R321 VDD N615 0.001
M641 N615 N664 N665 N615 pmos l=0.9u w=10u
M642 N665 N664 0 0 nmos l=0.9u w=10u
R322 VDD N616 0.001
M643 N616 N665 N666 N616 pmos l=0.9u w=10u
M644 N666 N665 0 0 nmos l=0.9u w=10u
R323 VDD N617 0.001
M645 N617 N666 N667 N617 pmos l=0.9u w=10u
M646 N667 N666 0 0 nmos l=0.9u w=10u
R324 VDD N618 0.001
M647 N618 N667 N668 N618 pmos l=0.9u w=10u
M648 N668 N667 0 0 nmos l=0.9u w=10u
R325 VDD N619 0.001
M649 N619 N668 N669 N619 pmos l=0.9u w=10u
M650 N669 N668 0 0 nmos l=0.9u w=10u
R326 VDD N620 0.001
M651 N620 N669 N670 N620 pmos l=0.9u w=10u
M652 N670 N669 0 0 nmos l=0.9u w=10u
R327 VDD N621 0.001
M653 N621 N670 N671 N621 pmos l=0.9u w=10u
M654 N671 N670 0 0 nmos l=0.9u w=10u
R328 VDD N622 0.001
M655 N622 N671 N672 N622 pmos l=0.9u w=10u
M656 N672 N671 0 0 nmos l=0.9u w=10u
R329 VDD N623 0.001
M657 N623 N672 N673 N623 pmos l=0.9u w=10u
M658 N673 N672 0 0 nmos l=0.9u w=10u
R330 VDD N624 0.001
M659 N624 N673 N674 N624 pmos l=0.9u w=10u
M660 N674 N673 0 0 nmos l=0.9u w=10u
R331 VDD N625 0.001
M661 N625 N674 N675 N625 pmos l=0.9u w=10u
M662 N675 N674 0 0 nmos l=0.9u w=10u
R332 VDD N626 0.001
M663 N626 N675 N676 N626 pmos l=0.9u w=10u
M664 N676 N675 0 0 nmos l=0.9u w=10u
R333 VDD N627 0.001
M665 N627 N676 N677 N627 pmos l=0.9u w=10u
M666 N677 N676 0 0 nmos l=0.9u w=10u
R334 VDD N628 0.001
M667 N628 N677 N678 N628 pmos l=0.9u w=10u
M668 N678 N677 0 0 nmos l=0.9u w=10u
R335 VDD N629 0.001
M669 N629 N678 N679 N629 pmos l=0.9u w=10u
M670 N679 N678 0 0 nmos l=0.9u w=10u
R336 VDD N630 0.001
M671 N630 N679 N680 N630 pmos l=0.9u w=10u
M672 N680 N679 0 0 nmos l=0.9u w=10u
R337 VDD N631 0.001
M673 N631 N680 N681 N631 pmos l=0.9u w=10u
M674 N681 N680 0 0 nmos l=0.9u w=10u
R338 VDD N632 0.001
M675 N632 N681 N682 N632 pmos l=0.9u w=10u
M676 N682 N681 0 0 nmos l=0.9u w=10u
R339 VDD N633 0.001
M677 N633 N682 N683 N633 pmos l=0.9u w=10u
M678 N683 N682 0 0 nmos l=0.9u w=10u
R340 VDD N634 0.001
M679 N634 N683 N684 N634 pmos l=0.9u w=10u
M680 N684 N683 0 0 nmos l=0.9u w=10u
R341 VDD N635 0.001
M681 N635 N684 N685 N635 pmos l=0.9u w=10u
M682 N685 N684 0 0 nmos l=0.9u w=10u
R342 VDD N636 0.001
M683 N636 N685 N686 N636 pmos l=0.9u w=10u
M684 N686 N685 0 0 nmos l=0.9u w=10u
R343 VDD N637 0.001
M685 N637 N686 N687 N637 pmos l=0.9u w=10u
M686 N687 N686 0 0 nmos l=0.9u w=10u
R344 VDD N638 0.001
M687 N638 N687 N688 N638 pmos l=0.9u w=10u
M688 N688 N687 0 0 nmos l=0.9u w=10u
R345 VDD N639 0.001
M689 N639 N688 N689 N639 pmos l=0.9u w=10u
M690 N689 N688 0 0 nmos l=0.9u w=10u
R346 VDD N640 0.001
M691 N640 N689 N690 N640 pmos l=0.9u w=10u
M692 N690 N689 0 0 nmos l=0.9u w=10u
R347 VDD N641 0.001
M693 N641 N690 N691 N641 pmos l=0.9u w=10u
M694 N691 N690 0 0 nmos l=0.9u w=10u
R348 VDD N642 0.001
M695 N642 N691 N692 N642 pmos l=0.9u w=10u
M696 N692 N691 0 0 nmos l=0.9u w=10u
R349 VDD N643 0.001
M697 N643 N692 N693 N643 pmos l=0.9u w=10u
M698 N693 N692 0 0 nmos l=0.9u w=10u
R350 VDD N644 0.001
M699 N644 N693 vout7 N644 pmos l=0.9u w=10u
M700 vout7 N693 0 0 nmos l=0.9u w=10u
R351 VDD N694 0.001
M701 N694 vout7 N744 N694 pmos l=0.9u w=10u
M702 N744 vout7 0 0 nmos l=0.9u w=10u
R352 VDD N695 0.001
M703 N695 N744 N745 N695 pmos l=0.9u w=10u
M704 N745 N744 0 0 nmos l=0.9u w=10u
R353 VDD N696 0.001
M705 N696 N745 N746 N696 pmos l=0.9u w=10u
M706 N746 N745 0 0 nmos l=0.9u w=10u
R354 VDD N697 0.001
M707 N697 N746 N747 N697 pmos l=0.9u w=10u
M708 N747 N746 0 0 nmos l=0.9u w=10u
R355 VDD N698 0.001
M709 N698 N747 N748 N698 pmos l=0.9u w=10u
M710 N748 N747 0 0 nmos l=0.9u w=10u
R356 VDD N699 0.001
M711 N699 N748 N749 N699 pmos l=0.9u w=10u
M712 N749 N748 0 0 nmos l=0.9u w=10u
R357 VDD N700 0.001
M713 N700 N749 N750 N700 pmos l=0.9u w=10u
M714 N750 N749 0 0 nmos l=0.9u w=10u
R358 VDD N701 0.001
M715 N701 N750 N751 N701 pmos l=0.9u w=10u
M716 N751 N750 0 0 nmos l=0.9u w=10u
R359 VDD N702 0.001
M717 N702 N751 N752 N702 pmos l=0.9u w=10u
M718 N752 N751 0 0 nmos l=0.9u w=10u
R360 VDD N703 0.001
M719 N703 N752 N753 N703 pmos l=0.9u w=10u
M720 N753 N752 0 0 nmos l=0.9u w=10u
R361 VDD N704 0.001
M721 N704 N753 N754 N704 pmos l=0.9u w=10u
M722 N754 N753 0 0 nmos l=0.9u w=10u
R362 VDD N705 0.001
M723 N705 N754 N755 N705 pmos l=0.9u w=10u
M724 N755 N754 0 0 nmos l=0.9u w=10u
R363 VDD N706 0.001
M725 N706 N755 N756 N706 pmos l=0.9u w=10u
M726 N756 N755 0 0 nmos l=0.9u w=10u
R364 VDD N707 0.001
M727 N707 N756 N757 N707 pmos l=0.9u w=10u
M728 N757 N756 0 0 nmos l=0.9u w=10u
R365 VDD N708 0.001
M729 N708 N757 N758 N708 pmos l=0.9u w=10u
M730 N758 N757 0 0 nmos l=0.9u w=10u
R366 VDD N709 0.001
M731 N709 N758 N759 N709 pmos l=0.9u w=10u
M732 N759 N758 0 0 nmos l=0.9u w=10u
R367 VDD N710 0.001
M733 N710 N759 N760 N710 pmos l=0.9u w=10u
M734 N760 N759 0 0 nmos l=0.9u w=10u
R368 VDD N711 0.001
M735 N711 N760 N761 N711 pmos l=0.9u w=10u
M736 N761 N760 0 0 nmos l=0.9u w=10u
R369 VDD N712 0.001
M737 N712 N761 N762 N712 pmos l=0.9u w=10u
M738 N762 N761 0 0 nmos l=0.9u w=10u
R370 VDD N713 0.001
M739 N713 N762 N763 N713 pmos l=0.9u w=10u
M740 N763 N762 0 0 nmos l=0.9u w=10u
R371 VDD N714 0.001
M741 N714 N763 N764 N714 pmos l=0.9u w=10u
M742 N764 N763 0 0 nmos l=0.9u w=10u
R372 VDD N715 0.001
M743 N715 N764 N765 N715 pmos l=0.9u w=10u
M744 N765 N764 0 0 nmos l=0.9u w=10u
R373 VDD N716 0.001
M745 N716 N765 N766 N716 pmos l=0.9u w=10u
M746 N766 N765 0 0 nmos l=0.9u w=10u
R374 VDD N717 0.001
M747 N717 N766 N767 N717 pmos l=0.9u w=10u
M748 N767 N766 0 0 nmos l=0.9u w=10u
R375 VDD N718 0.001
M749 N718 N767 N768 N718 pmos l=0.9u w=10u
M750 N768 N767 0 0 nmos l=0.9u w=10u
R376 VDD N719 0.001
M751 N719 N768 N769 N719 pmos l=0.9u w=10u
M752 N769 N768 0 0 nmos l=0.9u w=10u
R377 VDD N720 0.001
M753 N720 N769 N770 N720 pmos l=0.9u w=10u
M754 N770 N769 0 0 nmos l=0.9u w=10u
R378 VDD N721 0.001
M755 N721 N770 N771 N721 pmos l=0.9u w=10u
M756 N771 N770 0 0 nmos l=0.9u w=10u
R379 VDD N722 0.001
M757 N722 N771 N772 N722 pmos l=0.9u w=10u
M758 N772 N771 0 0 nmos l=0.9u w=10u
R380 VDD N723 0.001
M759 N723 N772 N773 N723 pmos l=0.9u w=10u
M760 N773 N772 0 0 nmos l=0.9u w=10u
R381 VDD N724 0.001
M761 N724 N773 N774 N724 pmos l=0.9u w=10u
M762 N774 N773 0 0 nmos l=0.9u w=10u
R382 VDD N725 0.001
M763 N725 N774 N775 N725 pmos l=0.9u w=10u
M764 N775 N774 0 0 nmos l=0.9u w=10u
R383 VDD N726 0.001
M765 N726 N775 N776 N726 pmos l=0.9u w=10u
M766 N776 N775 0 0 nmos l=0.9u w=10u
R384 VDD N727 0.001
M767 N727 N776 N777 N727 pmos l=0.9u w=10u
M768 N777 N776 0 0 nmos l=0.9u w=10u
R385 VDD N728 0.001
M769 N728 N777 N778 N728 pmos l=0.9u w=10u
M770 N778 N777 0 0 nmos l=0.9u w=10u
R386 VDD N729 0.001
M771 N729 N778 N779 N729 pmos l=0.9u w=10u
M772 N779 N778 0 0 nmos l=0.9u w=10u
R387 VDD N730 0.001
M773 N730 N779 N780 N730 pmos l=0.9u w=10u
M774 N780 N779 0 0 nmos l=0.9u w=10u
R388 VDD N731 0.001
M775 N731 N780 N781 N731 pmos l=0.9u w=10u
M776 N781 N780 0 0 nmos l=0.9u w=10u
R389 VDD N732 0.001
M777 N732 N781 N782 N732 pmos l=0.9u w=10u
M778 N782 N781 0 0 nmos l=0.9u w=10u
R390 VDD N733 0.001
M779 N733 N782 N783 N733 pmos l=0.9u w=10u
M780 N783 N782 0 0 nmos l=0.9u w=10u
R391 VDD N734 0.001
M781 N734 N783 N784 N734 pmos l=0.9u w=10u
M782 N784 N783 0 0 nmos l=0.9u w=10u
R392 VDD N735 0.001
M783 N735 N784 N785 N735 pmos l=0.9u w=10u
M784 N785 N784 0 0 nmos l=0.9u w=10u
R393 VDD N736 0.001
M785 N736 N785 N786 N736 pmos l=0.9u w=10u
M786 N786 N785 0 0 nmos l=0.9u w=10u
R394 VDD N737 0.001
M787 N737 N786 N787 N737 pmos l=0.9u w=10u
M788 N787 N786 0 0 nmos l=0.9u w=10u
R395 VDD N738 0.001
M789 N738 N787 N788 N738 pmos l=0.9u w=10u
M790 N788 N787 0 0 nmos l=0.9u w=10u
R396 VDD N739 0.001
M791 N739 N788 N789 N739 pmos l=0.9u w=10u
M792 N789 N788 0 0 nmos l=0.9u w=10u
R397 VDD N740 0.001
M793 N740 N789 N790 N740 pmos l=0.9u w=10u
M794 N790 N789 0 0 nmos l=0.9u w=10u
R398 VDD N741 0.001
M795 N741 N790 N791 N741 pmos l=0.9u w=10u
M796 N791 N790 0 0 nmos l=0.9u w=10u
R399 VDD N742 0.001
M797 N742 N791 N792 N742 pmos l=0.9u w=10u
M798 N792 N791 0 0 nmos l=0.9u w=10u
R400 VDD N743 0.001
M799 N743 N792 vout8 N743 pmos l=0.9u w=10u
M800 vout8 N792 0 0 nmos l=0.9u w=10u
R401 VDD N793 0.001
M801 N793 vout8 N843 N793 pmos l=0.9u w=10u
M802 N843 vout8 0 0 nmos l=0.9u w=10u
R402 VDD N794 0.001
M803 N794 N843 N844 N794 pmos l=0.9u w=10u
M804 N844 N843 0 0 nmos l=0.9u w=10u
R403 VDD N795 0.001
M805 N795 N844 N845 N795 pmos l=0.9u w=10u
M806 N845 N844 0 0 nmos l=0.9u w=10u
R404 VDD N796 0.001
M807 N796 N845 N846 N796 pmos l=0.9u w=10u
M808 N846 N845 0 0 nmos l=0.9u w=10u
R405 VDD N797 0.001
M809 N797 N846 N847 N797 pmos l=0.9u w=10u
M810 N847 N846 0 0 nmos l=0.9u w=10u
R406 VDD N798 0.001
M811 N798 N847 N848 N798 pmos l=0.9u w=10u
M812 N848 N847 0 0 nmos l=0.9u w=10u
R407 VDD N799 0.001
M813 N799 N848 N849 N799 pmos l=0.9u w=10u
M814 N849 N848 0 0 nmos l=0.9u w=10u
R408 VDD N800 0.001
M815 N800 N849 N850 N800 pmos l=0.9u w=10u
M816 N850 N849 0 0 nmos l=0.9u w=10u
R409 VDD N801 0.001
M817 N801 N850 N851 N801 pmos l=0.9u w=10u
M818 N851 N850 0 0 nmos l=0.9u w=10u
R410 VDD N802 0.001
M819 N802 N851 N852 N802 pmos l=0.9u w=10u
M820 N852 N851 0 0 nmos l=0.9u w=10u
R411 VDD N803 0.001
M821 N803 N852 N853 N803 pmos l=0.9u w=10u
M822 N853 N852 0 0 nmos l=0.9u w=10u
R412 VDD N804 0.001
M823 N804 N853 N854 N804 pmos l=0.9u w=10u
M824 N854 N853 0 0 nmos l=0.9u w=10u
R413 VDD N805 0.001
M825 N805 N854 N855 N805 pmos l=0.9u w=10u
M826 N855 N854 0 0 nmos l=0.9u w=10u
R414 VDD N806 0.001
M827 N806 N855 N856 N806 pmos l=0.9u w=10u
M828 N856 N855 0 0 nmos l=0.9u w=10u
R415 VDD N807 0.001
M829 N807 N856 N857 N807 pmos l=0.9u w=10u
M830 N857 N856 0 0 nmos l=0.9u w=10u
R416 VDD N808 0.001
M831 N808 N857 N858 N808 pmos l=0.9u w=10u
M832 N858 N857 0 0 nmos l=0.9u w=10u
R417 VDD N809 0.001
M833 N809 N858 N859 N809 pmos l=0.9u w=10u
M834 N859 N858 0 0 nmos l=0.9u w=10u
R418 VDD N810 0.001
M835 N810 N859 N860 N810 pmos l=0.9u w=10u
M836 N860 N859 0 0 nmos l=0.9u w=10u
R419 VDD N811 0.001
M837 N811 N860 N861 N811 pmos l=0.9u w=10u
M838 N861 N860 0 0 nmos l=0.9u w=10u
R420 VDD N812 0.001
M839 N812 N861 N862 N812 pmos l=0.9u w=10u
M840 N862 N861 0 0 nmos l=0.9u w=10u
R421 VDD N813 0.001
M841 N813 N862 N863 N813 pmos l=0.9u w=10u
M842 N863 N862 0 0 nmos l=0.9u w=10u
R422 VDD N814 0.001
M843 N814 N863 N864 N814 pmos l=0.9u w=10u
M844 N864 N863 0 0 nmos l=0.9u w=10u
R423 VDD N815 0.001
M845 N815 N864 N865 N815 pmos l=0.9u w=10u
M846 N865 N864 0 0 nmos l=0.9u w=10u
R424 VDD N816 0.001
M847 N816 N865 N866 N816 pmos l=0.9u w=10u
M848 N866 N865 0 0 nmos l=0.9u w=10u
R425 VDD N817 0.001
M849 N817 N866 N867 N817 pmos l=0.9u w=10u
M850 N867 N866 0 0 nmos l=0.9u w=10u
R426 VDD N818 0.001
M851 N818 N867 N868 N818 pmos l=0.9u w=10u
M852 N868 N867 0 0 nmos l=0.9u w=10u
R427 VDD N819 0.001
M853 N819 N868 N869 N819 pmos l=0.9u w=10u
M854 N869 N868 0 0 nmos l=0.9u w=10u
R428 VDD N820 0.001
M855 N820 N869 N870 N820 pmos l=0.9u w=10u
M856 N870 N869 0 0 nmos l=0.9u w=10u
R429 VDD N821 0.001
M857 N821 N870 N871 N821 pmos l=0.9u w=10u
M858 N871 N870 0 0 nmos l=0.9u w=10u
R430 VDD N822 0.001
M859 N822 N871 N872 N822 pmos l=0.9u w=10u
M860 N872 N871 0 0 nmos l=0.9u w=10u
R431 VDD N823 0.001
M861 N823 N872 N873 N823 pmos l=0.9u w=10u
M862 N873 N872 0 0 nmos l=0.9u w=10u
R432 VDD N824 0.001
M863 N824 N873 N874 N824 pmos l=0.9u w=10u
M864 N874 N873 0 0 nmos l=0.9u w=10u
R433 VDD N825 0.001
M865 N825 N874 N875 N825 pmos l=0.9u w=10u
M866 N875 N874 0 0 nmos l=0.9u w=10u
R434 VDD N826 0.001
M867 N826 N875 N876 N826 pmos l=0.9u w=10u
M868 N876 N875 0 0 nmos l=0.9u w=10u
R435 VDD N827 0.001
M869 N827 N876 N877 N827 pmos l=0.9u w=10u
M870 N877 N876 0 0 nmos l=0.9u w=10u
R436 VDD N828 0.001
M871 N828 N877 N878 N828 pmos l=0.9u w=10u
M872 N878 N877 0 0 nmos l=0.9u w=10u
R437 VDD N829 0.001
M873 N829 N878 N879 N829 pmos l=0.9u w=10u
M874 N879 N878 0 0 nmos l=0.9u w=10u
R438 VDD N830 0.001
M875 N830 N879 N880 N830 pmos l=0.9u w=10u
M876 N880 N879 0 0 nmos l=0.9u w=10u
R439 VDD N831 0.001
M877 N831 N880 N881 N831 pmos l=0.9u w=10u
M878 N881 N880 0 0 nmos l=0.9u w=10u
R440 VDD N832 0.001
M879 N832 N881 N882 N832 pmos l=0.9u w=10u
M880 N882 N881 0 0 nmos l=0.9u w=10u
R441 VDD N833 0.001
M881 N833 N882 N883 N833 pmos l=0.9u w=10u
M882 N883 N882 0 0 nmos l=0.9u w=10u
R442 VDD N834 0.001
M883 N834 N883 N884 N834 pmos l=0.9u w=10u
M884 N884 N883 0 0 nmos l=0.9u w=10u
R443 VDD N835 0.001
M885 N835 N884 N885 N835 pmos l=0.9u w=10u
M886 N885 N884 0 0 nmos l=0.9u w=10u
R444 VDD N836 0.001
M887 N836 N885 N886 N836 pmos l=0.9u w=10u
M888 N886 N885 0 0 nmos l=0.9u w=10u
R445 VDD N837 0.001
M889 N837 N886 N887 N837 pmos l=0.9u w=10u
M890 N887 N886 0 0 nmos l=0.9u w=10u
R446 VDD N838 0.001
M891 N838 N887 N888 N838 pmos l=0.9u w=10u
M892 N888 N887 0 0 nmos l=0.9u w=10u
R447 VDD N839 0.001
M893 N839 N888 N889 N839 pmos l=0.9u w=10u
M894 N889 N888 0 0 nmos l=0.9u w=10u
R448 VDD N840 0.001
M895 N840 N889 N890 N840 pmos l=0.9u w=10u
M896 N890 N889 0 0 nmos l=0.9u w=10u
R449 VDD N841 0.001
M897 N841 N890 N891 N841 pmos l=0.9u w=10u
M898 N891 N890 0 0 nmos l=0.9u w=10u
R450 VDD N842 0.001
M899 N842 N891 vout9 N842 pmos l=0.9u w=10u
M900 vout9 N891 0 0 nmos l=0.9u w=10u
R451 VDD N892 0.001
M901 N892 vout9 N942 N892 pmos l=0.9u w=10u
M902 N942 vout9 0 0 nmos l=0.9u w=10u
R452 VDD N893 0.001
M903 N893 N942 N943 N893 pmos l=0.9u w=10u
M904 N943 N942 0 0 nmos l=0.9u w=10u
R453 VDD N894 0.001
M905 N894 N943 N944 N894 pmos l=0.9u w=10u
M906 N944 N943 0 0 nmos l=0.9u w=10u
R454 VDD N895 0.001
M907 N895 N944 N945 N895 pmos l=0.9u w=10u
M908 N945 N944 0 0 nmos l=0.9u w=10u
R455 VDD N896 0.001
M909 N896 N945 N946 N896 pmos l=0.9u w=10u
M910 N946 N945 0 0 nmos l=0.9u w=10u
R456 VDD N897 0.001
M911 N897 N946 N947 N897 pmos l=0.9u w=10u
M912 N947 N946 0 0 nmos l=0.9u w=10u
R457 VDD N898 0.001
M913 N898 N947 N948 N898 pmos l=0.9u w=10u
M914 N948 N947 0 0 nmos l=0.9u w=10u
R458 VDD N899 0.001
M915 N899 N948 N949 N899 pmos l=0.9u w=10u
M916 N949 N948 0 0 nmos l=0.9u w=10u
R459 VDD N900 0.001
M917 N900 N949 N950 N900 pmos l=0.9u w=10u
M918 N950 N949 0 0 nmos l=0.9u w=10u
R460 VDD N901 0.001
M919 N901 N950 N951 N901 pmos l=0.9u w=10u
M920 N951 N950 0 0 nmos l=0.9u w=10u
R461 VDD N902 0.001
M921 N902 N951 N952 N902 pmos l=0.9u w=10u
M922 N952 N951 0 0 nmos l=0.9u w=10u
R462 VDD N903 0.001
M923 N903 N952 N953 N903 pmos l=0.9u w=10u
M924 N953 N952 0 0 nmos l=0.9u w=10u
R463 VDD N904 0.001
M925 N904 N953 N954 N904 pmos l=0.9u w=10u
M926 N954 N953 0 0 nmos l=0.9u w=10u
R464 VDD N905 0.001
M927 N905 N954 N955 N905 pmos l=0.9u w=10u
M928 N955 N954 0 0 nmos l=0.9u w=10u
R465 VDD N906 0.001
M929 N906 N955 N956 N906 pmos l=0.9u w=10u
M930 N956 N955 0 0 nmos l=0.9u w=10u
R466 VDD N907 0.001
M931 N907 N956 N957 N907 pmos l=0.9u w=10u
M932 N957 N956 0 0 nmos l=0.9u w=10u
R467 VDD N908 0.001
M933 N908 N957 N958 N908 pmos l=0.9u w=10u
M934 N958 N957 0 0 nmos l=0.9u w=10u
R468 VDD N909 0.001
M935 N909 N958 N959 N909 pmos l=0.9u w=10u
M936 N959 N958 0 0 nmos l=0.9u w=10u
R469 VDD N910 0.001
M937 N910 N959 N960 N910 pmos l=0.9u w=10u
M938 N960 N959 0 0 nmos l=0.9u w=10u
R470 VDD N911 0.001
M939 N911 N960 N961 N911 pmos l=0.9u w=10u
M940 N961 N960 0 0 nmos l=0.9u w=10u
R471 VDD N912 0.001
M941 N912 N961 N962 N912 pmos l=0.9u w=10u
M942 N962 N961 0 0 nmos l=0.9u w=10u
R472 VDD N913 0.001
M943 N913 N962 N963 N913 pmos l=0.9u w=10u
M944 N963 N962 0 0 nmos l=0.9u w=10u
R473 VDD N914 0.001
M945 N914 N963 N964 N914 pmos l=0.9u w=10u
M946 N964 N963 0 0 nmos l=0.9u w=10u
R474 VDD N915 0.001
M947 N915 N964 N965 N915 pmos l=0.9u w=10u
M948 N965 N964 0 0 nmos l=0.9u w=10u
R475 VDD N916 0.001
M949 N916 N965 N966 N916 pmos l=0.9u w=10u
M950 N966 N965 0 0 nmos l=0.9u w=10u
R476 VDD N917 0.001
M951 N917 N966 N967 N917 pmos l=0.9u w=10u
M952 N967 N966 0 0 nmos l=0.9u w=10u
R477 VDD N918 0.001
M953 N918 N967 N968 N918 pmos l=0.9u w=10u
M954 N968 N967 0 0 nmos l=0.9u w=10u
R478 VDD N919 0.001
M955 N919 N968 N969 N919 pmos l=0.9u w=10u
M956 N969 N968 0 0 nmos l=0.9u w=10u
R479 VDD N920 0.001
M957 N920 N969 N970 N920 pmos l=0.9u w=10u
M958 N970 N969 0 0 nmos l=0.9u w=10u
R480 VDD N921 0.001
M959 N921 N970 N971 N921 pmos l=0.9u w=10u
M960 N971 N970 0 0 nmos l=0.9u w=10u
R481 VDD N922 0.001
M961 N922 N971 N972 N922 pmos l=0.9u w=10u
M962 N972 N971 0 0 nmos l=0.9u w=10u
R482 VDD N923 0.001
M963 N923 N972 N973 N923 pmos l=0.9u w=10u
M964 N973 N972 0 0 nmos l=0.9u w=10u
R483 VDD N924 0.001
M965 N924 N973 N974 N924 pmos l=0.9u w=10u
M966 N974 N973 0 0 nmos l=0.9u w=10u
R484 VDD N925 0.001
M967 N925 N974 N975 N925 pmos l=0.9u w=10u
M968 N975 N974 0 0 nmos l=0.9u w=10u
R485 VDD N926 0.001
M969 N926 N975 N976 N926 pmos l=0.9u w=10u
M970 N976 N975 0 0 nmos l=0.9u w=10u
R486 VDD N927 0.001
M971 N927 N976 N977 N927 pmos l=0.9u w=10u
M972 N977 N976 0 0 nmos l=0.9u w=10u
R487 VDD N928 0.001
M973 N928 N977 N978 N928 pmos l=0.9u w=10u
M974 N978 N977 0 0 nmos l=0.9u w=10u
R488 VDD N929 0.001
M975 N929 N978 N979 N929 pmos l=0.9u w=10u
M976 N979 N978 0 0 nmos l=0.9u w=10u
R489 VDD N930 0.001
M977 N930 N979 N980 N930 pmos l=0.9u w=10u
M978 N980 N979 0 0 nmos l=0.9u w=10u
R490 VDD N931 0.001
M979 N931 N980 N981 N931 pmos l=0.9u w=10u
M980 N981 N980 0 0 nmos l=0.9u w=10u
R491 VDD N932 0.001
M981 N932 N981 N982 N932 pmos l=0.9u w=10u
M982 N982 N981 0 0 nmos l=0.9u w=10u
R492 VDD N933 0.001
M983 N933 N982 N983 N933 pmos l=0.9u w=10u
M984 N983 N982 0 0 nmos l=0.9u w=10u
R493 VDD N934 0.001
M985 N934 N983 N984 N934 pmos l=0.9u w=10u
M986 N984 N983 0 0 nmos l=0.9u w=10u
R494 VDD N935 0.001
M987 N935 N984 N985 N935 pmos l=0.9u w=10u
M988 N985 N984 0 0 nmos l=0.9u w=10u
R495 VDD N936 0.001
M989 N936 N985 N986 N936 pmos l=0.9u w=10u
M990 N986 N985 0 0 nmos l=0.9u w=10u
R496 VDD N937 0.001
M991 N937 N986 N987 N937 pmos l=0.9u w=10u
M992 N987 N986 0 0 nmos l=0.9u w=10u
R497 VDD N938 0.001
M993 N938 N987 N988 N938 pmos l=0.9u w=10u
M994 N988 N987 0 0 nmos l=0.9u w=10u
R498 VDD N939 0.001
M995 N939 N988 N989 N939 pmos l=0.9u w=10u
M996 N989 N988 0 0 nmos l=0.9u w=10u
R499 VDD N940 0.001
M997 N940 N989 N990 N940 pmos l=0.9u w=10u
M998 N990 N989 0 0 nmos l=0.9u w=10u
R500 VDD N941 0.001
M999 N941 N990 vout10 N941 pmos l=0.9u w=10u
M1000 vout10 N990 0 0 nmos l=0.9u w=10u
C1 vout10 0 0.1u
.tran 1p 20n
.end
