11-Stage

V1 1 0 7

* Stage 1
M1 3 2 0 0 NMOS W=1u L=0.09u
M2 3 2 1 1 PMOS W=1u L=0.9u
R1 3 4 1
C1 4 0 0.1p
M3 5 4 0 0 NMOS W=10u L=0.09u
M4 5 4 1 1 PMOS W=10u L=0.9u
M5 6 5 0 0 NMOS W=10u L=0.09u
M6 6 5 1 1 PMOS W=10u L=0.09u

* Stage 2
M7 7 6 0 0 NMOS W=1u L=0.09u
M8 7 6 1 1 PMOS W=1u L=0.09u
R2 7 8 1
C2 8 0 0.1p
M9 9 8 0 0 NMOS W=10u L=0.9u
M10 9 8 1 1 PMOS W=10u L=0.9u
M11 10 9 0 0 NMOS W=10u L=0.9u
M12 10 9 1 1 PMOS W=10u L=0.09u

* Stage 3
M13 11 10 0 0 NMOS W=1u L=0.09u
M14 11 10 1 1 PMOS W=1u L=0.09u
R3 11 12 1
C3 12 0 0.1p
M15 13 12 0 0 NMOS W=10u L=0.9u
M16 13 12 1 1 PMOS W=10u L=0.9u
M17 14 13 0 0 NMOS W=10u L=0.9u
M18 14 13 1 1 PMOS W=10u L=0.09u

* Stage 4
M19 15 14 0 0 NMOS W=1u L=0.09u
M20 15 14 1 1 PMOS W=1u L=0.09u
R4 15 16 1
C4 16 0 0.1p
M21 17 16 0 0 NMOS W=10u L=0.9u
M22 17 16 1 1 PMOS W=10u L=0.9u
M23 18 17 0 0 NMOS W=10u L=0.9u
M24 18 17 1 1 PMOS W=10u L=0.09u

* Stage 5
M25 19 18 0 0 NMOS W=1u L=0.09u
M26 19 18 1 1 PMOS W=1u L=0.09u
R5 19 20 1
C5 20 0 0.1p
M27 21 20 0 0 NMOS W=10u L=0.9u
M28 21 20 1 1 PMOS W=10u L=0.9u
M29 22 21 0 0 NMOS W=10u L=0.9u
M30 22 21 1 1 PMOS W=10u L=0.09u

* Stage 6
M31 23 22 0 0 NMOS W=1u L=0.09u
M32 23 22 1 1 PMOS W=1u L=0.09u
R6 23 24 1
C6 24 0 0.1p
M33 25 24 0 0 NMOS W=10u L=0.9u
M34 25 24 1 1 PMOS W=10u L=0.9u
M35 26 25 0 0 NMOS W=10u L=0.9u
M36 26 25 1 1 PMOS W=10u L=0.09u

* Stage 7
M37 27 26 0 0 NMOS W=1u L=0.09u
M38 27 26 1 1 PMOS W=1u L=0.09u
R7 27 28 1
C7 28 0 0.1p
M39 29 28 0 0 NMOS W=10u L=0.9u
M40 29 28 1 1 PMOS W=10u L=0.9u
M41 30 29 0 0 NMOS W=10u L=0.9u
M42 30 29 1 1 PMOS W=10u L=0.09u

* Stage 8
M43 31 30 0 0 NMOS W=1u L=0.09u
M44 31 30 1 1 PMOS W=1u L=0.09u
R8 31 32 1
C8 32 0 0.1p
M45 33 32 0 0 NMOS W=10u L=0.9u
M46 33 32 1 1 PMOS W=10u L=0.9u
M47 34 33 0 0 NMOS W=10u L=0.9u
M48 34 33 1 1 PMOS W=10u L=0.09u

* Stage 9
M49 35 34 0 0 NMOS W=1u L=0.09u
M50 35 34 1 1 PMOS W=1u L=0.09u
R9 35 36 1
C9 36 0 0.1p
M51 37 36 0 0 NMOS W=10u L=0.9u
M52 37 36 1 1 PMOS W=10u L=0.9u
M53 38 37 0 0 NMOS W=10u L=0.9u
M54 38 37 1 1 PMOS W=10u L=0.09u

* Stage 10
M55 39 38 0 0 NMOS W=1u L=0.09u
M56 39 38 1 1 PMOS W=1u L=0.09u
R10 39 40 1
C10 40 0 0.1p
M57 41 40 0 0 NMOS W=10u L=0.9u
M58 41 40 1 1 PMOS W=10u L=0.9u
M59 42 41 0 0 NMOS W=10u L=0.9u
M60 42 41 1 1 PMOS W=10u L=0.09u

* Stage 11
M61 43 42 0 0 NMOS W=1u L=0.09u
M62 43 42 1 1 PMOS W=1u L=0.09u
R11 43 44 1
C11 44 0 0.1p
M63 45 44 0 0 NMOS W=10u L=0.9u
M64 45 44 1 1 PMOS W=10u L=0.9u
M65 46 45 0 0 NMOS W=10u L=0.9u
M66 46 45 1 1 PMOS W=10u L=0.09u

R12 46 2 1

.tran 1p 10n
