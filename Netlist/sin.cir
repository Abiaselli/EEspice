sine wave

V1 N001 0 sin (0 5 100 0 0 0)
R1 N002 N001 1k
C1 N002 0 0.1u
.tran 0.01 1

.end
