sine wave

V1 1 0 SIN (0 1 1k 1m 400 0)
R1 1 2 100
C1 2 0 1u

.tran 0.000001 0.006

.end
