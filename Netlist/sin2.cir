Netlist

V1 1 0 5

M1 3 2 1 1 PMOS W=10u L=0.09u
M2 3 2 0 0 NMOS W=10u L=0.09u
C1 2 0 0.1p

M3 4 3 1 1 PMOS W=10u L=0.09u
M4 4 3 0 0 NMOS W=10u L=0.09u
C2 3 0 0.1p

M5 5 4 1 1 PMOS W=10u L=0.09u
M6 5 4 0 0 NMOS W=10u L=0.09u
C3 4 0 0.1p

M7 6 5 1 1 PMOS W=10u L=0.09u
M8 6 5 0 0 NMOS W=10u L=0.09u
C4 5 0 0.1p

M9 7 6 1 1 PMOS W=10u L=0.09u
M10 7 6 0 0 NMOS W=10u L=0.09u
C5 6 0 0.1p

M11 8 7 1 1 PMOS W=10u L=0.09u
M12 8 7 0 0 NMOS W=10u L=0.09u
C6 7 0 0.1p

M13 9 8 1 1 PMOS W=10u L=0.09u
M14 9 8 0 0 NMOS W=10u L=0.09u
C7 8 0 0.1p

M15 10 9 1 1 PMOS W=10u L=0.09u
M16 10 9 0 0 NMOS W=10u L=0.09u
C8 9 0 0.1p

M17 11 10 1 1 PMOS W=10u L=0.09u
M18 11 10 0 0 NMOS W=10u L=0.09u
C9 10 0 0.1p

M19 12 11 1 1 PMOS W=10u L=0.09u
M20 12 11 0 0 NMOS W=10u L=0.09u
C10 11 0 0.1p

M21 2 12 1 1 PMOS W=10u L=0.09u
M22 2 12 0 0 NMOS W=10u L=0.09u
C11 12 0 0.1p

.tran 0.5p 5n
