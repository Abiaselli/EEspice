Test PMOS
.model PMOS pmos (level=14 version=4.8.2)
* V Gate
V2 2 0 5
* VDD
V1 1 0 5

* Mnumber d g s b model W=w L=l
M1 3 2 1 1 PMOS W=100u L=0.9u
R1 3 0 1

.dc V2 -5 0 1
