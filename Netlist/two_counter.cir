Two-Bit Counter Netlist with Transient Simulation

V1 1 0 1.8

R1 1 2 1m
C1 2 0 0.1p

* Clock Generation

V2 3 0 pulse (0 1.8 0 0.1n 0.1n 4.9n 10n)

* Reset Signal (active low)

V3 4 0 pulse (0 1.8 1n 1n 1n 47n 100n)

* DFF1 (LSB)

* NAND1 (Set)

M1 5 6 2 2 PMOS W=1u L=0.09u

M2 5 3 2 2 PMOS W=1u L=0.09u

M3 5 6 7 0 NMOS W=1u L=0.09u

M4 7 3 0 0 NMOS W=1u L=0.09u

* NAND2 (Reset)

M5 8 5 2 2 PMOS W=1u L=0.09u

M6 8 9 2 2 PMOS W=1u L=0.09u

M7 8 5 10 0 NMOS W=1u L=0.09u

M8 10 9 0 0 NMOS W=1u L=0.09u

* NAND3 (Latch part 1)

M9 11 8 2 2 PMOS W=1u L=0.09u

M10 11 12 2 2 PMOS W=1u L=0.09u

M11 11 8 13 0 NMOS W=1u L=0.09u

M12 13 12 0 0 NMOS W=1u L=0.09u

* NAND4 (Latch part 2)

M13 12 11 2 2 PMOS W=1u L=0.09u

M14 12 4 2 2 PMOS W=1u L=0.09u

M15 12 11 14 0 NMOS W=1u L=0.09u

M16 14 4 0 0 NMOS W=1u L=0.09u

* DFF2 (MSB)

* NAND1 (Set)

M17 15 16 2 2 PMOS W=1u L=0.09u

M18 15 11 2 2 PMOS W=1u L=0.09u

M19 15 16 17 0 NMOS W=1u L=0.09u

M20 17 11 0 0 NMOS W=1u L=0.09u

* NAND2 (Reset)

M21 18 15 2 2 PMOS W=1u L=0.09u

M22 18 12 2 2 PMOS W=1u L=0.09u

M23 18 15 19 0 NMOS W=1u L=0.09u

M24 19 12 0 0 NMOS W=1u L=0.09u

* NAND3 (Latch part 1)

M25 20 18 2 2 PMOS W=1u L=0.09u

M26 20 21 2 2 PMOS W=1u L=0.09u

M27 20 18 22 0 NMOS W=1u L=0.09u

M28 22 21 0 0 NMOS W=1u L=0.09u

* NAND4 (Latch part 2)

M29 21 20 2 2 PMOS W=1u L=0.09u

M30 21 4 2 2 PMOS W=1u L=0.09u

M31 21 20 23 0 NMOS W=1u L=0.09u

M32 23 4 0 0 NMOS W=1u L=0.09u

* Inverter for clock

M33 9 3 2 2 PMOS W=1u L=0.09u

M34 9 3 0 0 NMOS W=1u L=0.09u

* Connections

* Connect Q_n to D for toggle flip-flop behavior

R2 12 6 1k

R3 21 16 1k

* Transient Analysis

.tran 1p 100n
