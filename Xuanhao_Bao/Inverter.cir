Test Inverter
* VDD
V1 1 0 5
* V Gate
V2 3 0 pulse (0 5 0 9u 9u 2u 20u)
* V2 3 0 0

* Mnumber d g s b model W=w L=l
M1 2 3 1 1 PMOS W=10u L=10u
M2 2 3 0 0 NMOS W=10u L=10u

* Node 2 is output
* Node 3 is input

.tran 1u 40u
