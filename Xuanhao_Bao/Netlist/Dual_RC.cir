circuit netlist
* t1_pulse >> v1 >> v2 >> td >> tr >> tf >> pw >> per

V1 1 0 pulse (0 5 0 5u 5u 3u 20u)
R1 1 2 10k
C1 2 0 1f
C2 2 0 0.01f
C3 2 0 0.001f
C4 2 0 0.0001f
R2 2 3 10k
C5 3 0 10u

.tran 1u 20u
