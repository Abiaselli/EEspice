Test Inverter

* V Gate
V2 2 0 pulse (0 5 0 5u 5u 10u 25u)
*V2 2 0 5
* VDD
V1 1 0 5

R1 1 3 0.1
*Vg
R2 2 4 1
* Mnumber d g s b model W=w L=l
M1 5 4 3 9 PMOS W=100u L=10u
R3 5 6 0.2
R4 6 7 0.2
M2 7 4 8 10 NMOS W=10u L=10u
R5 8 0 0.1
R6 1 9 1
R7 10 0 1

* Node 6 is output
* Node 2 is input

.tran 0.1u 10u
