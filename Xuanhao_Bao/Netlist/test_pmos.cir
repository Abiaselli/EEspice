Test PMOS

* V Gate
V2 2 0 5
* VDD
V1 1 0 5

* Mnumber d g s b model W=w L=l
M1 3 2 1 1 PMOS W=10u L=0.9u
R1 3 0 1

.tran 0.1u 2u
