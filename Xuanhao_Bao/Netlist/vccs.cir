Basic RLC circuit

V2 2 0 0
V1 1 0 5

*PMOS
G1 1 3 1 2 0
R1 1 3 1000000000
*I1 1 3 0

*NMOS
*G2 2 0 3 0 1000
*R2 2 0 0
*I2 2 0 0

.tran 0.1 1
