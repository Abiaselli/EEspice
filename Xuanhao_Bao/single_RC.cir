netlist
V1 1 0 pulse 0 0 5 0 1e-9 1e-9 4e-3 4e-3
R1 1 2 10k
C1 2 0 1e-7

.tran 0 4e-3
