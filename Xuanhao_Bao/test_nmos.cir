Test NMOS

* VDD
V1 1 0 pulse (0 5 0 9u 9u 2u 20u)
* V Gate
V2 3 0 0.8

* Mnumber d g s b model W=w L=l
M1 2 3 0 0 NMOS W=10u L=10u
R1 1 2 1

.tran 1u 20u
